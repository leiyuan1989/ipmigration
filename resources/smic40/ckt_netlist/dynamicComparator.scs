//include "/home/shunqidai/Sizing/SizingDemoLinuxSpectre/smic018/models/spectre/ms018_v1p7_spe.lib" section=tt

parameters vdd=1.8 cload=1p

subckt dynamic_comp dd gnd inp inn clk outp outn
	M1  (net2 inn  net1 gnd)  n18 w=w1 l=l1
	M2  (net3 inp  net1 gnd)  n18 w=w1 l=l1
	M3  (net1 clk  gnd gnd)   n18 w=w3 l=l3

	M4  (on1 op1  net2 gnd)  n18 w=w4 l=l4
	M5  (op1 on1  net3 gnd)  n18 w=w4 l=l4
	M6  (on1 op1  dd   dd)   p18 w=w5 l=l5
	M7  (op1 on1  dd   dd)   p18 w=w5 l=l5

	M8  (on1 clk  dd   dd)   p18 w=w6 l=l6
	M9  (net2 clk  dd   dd)  p18 w=w6 l=l6
	M10  (op1 clk  dd   dd)   p18 w=w6 l=l6
	M11  (net3 clk  dd   dd)  p18 w=w6 l=l6

	M12  (outn  on1  gnd gnd)  n18 w=w7 l=l7
	M13  (outn  on1  dd dd)    p18 w=w8 l=l8

	M14  (outp  op1  gnd gnd)  n18 w=w7 l=l7
	M15  (outp  op1  dd dd)    p18 w=w8 l=l8

ends dynamic_comp
