// *LEVEL SHIFTER Characterization Testbench
// Transient simulation
simulator lang=spectre
global 0

// include model card
include "dummy_model_card_path" section=dummy_corner_name

parameters w1 = {w1}  l1 = {l1}  w2 = 0.5  l2 = 0.18  w3 = {w3}  l3 = {l3}  w4 = {w4}  l4 = {l4}  w5 = {w5}  l5 = {l5}  w6 = {w6}  l6 = {l6}   w7 = 1.0  l7 = 0.35

// the power supply 3.3 V and current bias
vddh    (ddh  0)   vsource  dc=vddh     type=dc
vddl    (ddl  0)   vsource  dc=vddl     type=dc

// the input signal for dc and tran simulation
vin    (in 0)     vsource  type=pulse	val0=0 val1=vddl delay=0 rise=0.05n fall=0.05n width=5n  period=10n

// the circuit
include    "/home/shunqidai/Sizing/SizingDemoLinuxSpectre_integer_stdcell/smic018/ckt_netlist/level_shifter_high_speed.scs"
Xlevel_shifter  (ddh ddl 0 in out)  level_shifter
cl 	   (out 0) 					capacitor  c=cload

// Sprctre Analyses and Output Options
// Output Options
simulatorOptions options
+    reltol=1e-3 vabstol=1e-6 iabstol=1e-12 temp=27
+    tnom=27 scalem=1.0 scale=1.0e-6 gmin=1e-12 rforce=1 maxnotes=5 maxwarns=5
+    digits=5 cols=80 pivrel=1e-3 sensfile="../psf/sens.output"
+    checklimitdest=psf

// Analyses
old_data_output_filename tran start=0.0 stop=0.1e-6 maxstep=0.01e-6 annotate=status
saveOptions options save=allpub subcktprobelvl=2

// end of file
