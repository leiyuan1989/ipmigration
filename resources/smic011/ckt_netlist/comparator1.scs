//include "/home/shunqidai/Sizing/SizingDemoLinuxSpectre/smic018/models/spectre/ms018_v1p7_spe.lib" section=tt

parameters vdd=3.3 cload=1p

subckt comp dd gnd inp inn out ibias
	M1  (net2 inn  net1 gnd)  n33 w=w1 l=l1
	M2  (net3 inp  net1 gnd)  n33 w=w1 l=l1
	M3  (net1 ibias  gnd gnd)   n33 w=w2 l=l2

	M4  (net2 net2  dd dd)  p33 w=w3 l=l3
	M5  (net3 net2  dd dd)  p33 w=w3 l=l3

	M6  (out ibias  gnd  gnd)   n33 w=w4 l=l4
	M7  (out net3  dd  dd)   p33 w=w5 l=l5

	M8  (ibias ibias  gnd   gnd)  n33 w=w6 l=l6
ends comp
