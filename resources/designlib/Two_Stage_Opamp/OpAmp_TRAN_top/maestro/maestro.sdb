ADE simulation setup
Run mode: Single Run, Sweeps and Corners
Tests:
  Two_Stage_Opamp:OpAmp_TRAN_top:1: Two_Stage_Opamp/OpAmp_TRAN_top/schematic, simulator spectre
    Variables: cload = 1p; rload = 1K; temp1 = 27; sim_time = 1e-07; cont = 2.5; rend = 0; R0_r = 500; M9_M10_fingers_ratio = 4; M8_M6_fingers_ratio = 5; M7_M6_fingers_ratio = 3; M6_l = 900n; M6_fw = 8u; M6_fingers = 2; M5_l = 280n; M5_fw = 1.6e-05; M5_fingers = 32; M3_l = 1.76u; M3_fw = 11u; M3_fingers = 8; M1_l = 1.48u; M1_fw = 20u; M1_fingers = 20; M10_l = 700n; M10_fw = 12u; M10_fingers = 10; C0_w = 2.1155e-05; C0_m = 16; C0_c = 600f; vdd = 1.8
