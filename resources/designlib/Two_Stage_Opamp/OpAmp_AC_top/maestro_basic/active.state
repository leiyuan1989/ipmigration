ADE simulation setup
Test Two_Stage_Opamp:OpAmp_AC_top:1: Two_Stage_Opamp/OpAmp_AC_top/schematic, simulator spectre
  Models: gpdk045.scs[mc]
  Variables: cload = 500f; rload = 1K ; vdd = 1.3
  Temperature: 27
  Analysis ac: start=1 stop=10G
  Analysis dc: (saves the operating point)
  Analysis xf: start=1 stop=1G dec=10 p=/OUT n=/gnd!
  Output Current = abs(IDC("/V1/PLUS"))
  Output UGF = cross(dB20(mag(VF("/OUT"))) 0 1 "falling")
  Output Gain = value(dB20(mag(VF("/OUT"))) 1)
  Output Voffset = (VDC("/inm") - VDC("/inp"))
  Output CMRR = (value(dB20(mag(VF("/OUT"))) 1) - value(db(getData("/Vcm" ?result "xf")) 1))
  Output GainVsupply1 = value(db(getData("/V1" ?result "xf")) 1)
  Output PSRR = (value(dB20(mag(VF("/OUT"))) 1) - value(db(getData("/V1" ?result "xf")) 1))
  Output GainCm = value(db(getData("/Vcm" ?result "xf")) 1)
  Signals: /V1/PLUS (terminal), /OUT
