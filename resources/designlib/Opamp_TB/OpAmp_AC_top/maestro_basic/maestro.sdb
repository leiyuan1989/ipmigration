ADE simulation setup
Run mode: Single Run, Sweeps and Corners
Tests:
  Two_Stage_Opamp:OpAmp_AC_top:1: Two_Stage_Opamp/OpAmp_AC_top/schematic, simulator spectre
    Variables: cload = 500f; rload = 1K; vdd = 1.3
    Outputs: GainVsupply1; 5.0; GainCm; CMRR; PSRR
Specs:
  Two_Stage_Opamp:OpAmp_AC_top:1 / Gain: > 44
  Two_Stage_Opamp:OpAmp_AC_top:1 / Current: < 1.5m
  Two_Stage_Opamp:OpAmp_AC_top:1 / UGF: > 533M
  Two_Stage_Opamp:OpAmp_AC_top:1 / Voffset: range -10m to 10m
