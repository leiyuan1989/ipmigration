ADE simulation setup
Run mode: Single Run, Sweeps and Corners
Tests:
  AC: Two_Stage_Opamp/OpAmp_AC_top/schematic, simulator spectre
    Variables: cload = 100f; rload = 1K; vdd = 1.3:1:1.5
    Outputs: ocnMeasure_0; IDC("/I0/M1/D"); IDC("/I0/NM0/D"); IDC("/I0/M3/D"); IDC("/I0/M4/D"); IDC("/I0/M6/D"); IDC("/I0/M7/D"); IDC("/I0/M8/D"); IDC("/I0/M5/D"); ocnMeasure_1; Voffset [V]; Gain [dB]; UGF [Hz]; Current [A]; average(Current); VAR("nom)) "); VAR("nomGain")
  TRAN: Two_Stage_Opamp/OpAmp_TRAN_top/schematic, simulator spectre
    Variables: cload = 100f; rload = 1K; vdd = 1.2 1.3
    Outputs: SettlingTimex; RelativeSwingPercent [%]; SettlingTime [s]; PhaseMargin [degree]
Global variables:
  rload = 1K
  cload = 100f
  vdd = 1.3:0.1:1.5
  nomGain = 0
Corners:
  Fast: temperature=-40; gpdk045.scs[ff]
  Slow: temperature=110; gpdk045.scs[ss]
  Typical: temperature=30; gpdk045.scs[tt]
Specs:
  AC / UGF: > 533M
  AC / Gain: > 44
  TRAN / Swing: > 0.98
  TRAN / SettlingTime: < 8n
  AC / Voffset: range -10m to 10m
  TRAN / RelativeSwingPercent: > 75
  TRAN / PhaseMargin: > 19.4
  AC / Current: < 1.5m
Single Run, Sweeps and Corners options: submitpointsenabled=0
