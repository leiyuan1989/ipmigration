ADE simulation setup
Test AC: Two_Stage_Opamp/OpAmp_AC_top/schematic, simulator spectre
  Models: gpdk045.scs[mc]
  Variables: cload = 100f; rload = 1K; vdd = 1.3:1:1.5
  Temperature: 27
  Analysis dc: (saves the operating point)
  Analysis ac: start=1 stop=10G dec=20
  Output Current = abs(IDC("/V1/PLUS"))
  Output UGF = cross(dB20(mag(VF("/OUT"))) 0 1 "falling")
  Output Gain = value(dB20(mag(VF("/OUT"))) 1)
  Output Voffset = (VDC("/inm") - VDC("/inp"))
  Output VAR("nomGain")
  Signals: /V1/PLUS (terminal), /OUT, /inm, /inp, /cmin
Test TRAN: Two_Stage_Opamp/OpAmp_TRAN_top/schematic, simulator spectre
  Models: gpdk045.scs[mc]
  Variables: cload = 100f; rload = 1K; vdd = 1.3
  Temperature: 27
  Simulator options: additionalArgs=inlinesubcktcurrent=subkt
  Analysis dc: (saves the operating point)
  Analysis tran: stop=30n errpreset=moderate
  Analysis stb: start=1 stop=1G dec=10 probe=/VFB stbProbeMode=differential
  Output Swing = (value(VT("/OUT") 2.5e-08) - value(VT("/OUT") 1e-09))
  Output SettlingTime = settlingTime(VT("/OUT") 0 t 2.5e-08 t 10 nil "time")
  Output RelativeSwingPercent = ((Swing / VAR("vdd")) * 100)
  Output PhaseMargin = getData("/phaseMargin" ?result "stb_margin")
  Signals: /OUT
Run mode: Single Run, Sweeps and Corners
Global variables:
  rload = 1K
  cload = 100f
  vdd = 1.3:0.1:1.5
  nomGain = 0
Corners:
  Fast: temperature=-40; gpdk045.scs[ff]
  Slow: temperature=110; gpdk045.scs[ss]
  Typical: temperature=30; gpdk045.scs[tt]
Specs:
  AC / UGF: > 533M
  AC / Gain: > 44
  TRAN / Swing: > 0.98
  TRAN / SettlingTime: < 8n
  AC / Voffset: range -10m to 10m
  TRAN / RelativeSwingPercent: > 75
  TRAN / PhaseMargin: > 19.4
  AC / Current: < 1.5m
Single Run, Sweeps and Corners options: submitpointsenabled=0
Setup values for test TRAN: vdd = 1.2 1.3
Disabled tests: AC_orig, CMRR_Calculation, OpenLoop_AC, OpenLoop_OffsetMeasurement, TRAN_orig
