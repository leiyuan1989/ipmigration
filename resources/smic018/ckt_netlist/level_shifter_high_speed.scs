//include "/home/shunqidai/Sizing/SizingDemoLinuxSpectre_integer_stdcell/smic018/models/spectre/ms018_v1p7_spe.lib" section=tt

// *LEVEL SHIFTER HIGH SPEED
parameters vddl=1.8 vddh=3.3 cload=100f

subckt level_shifter ddh ddl gnd in out
	MP1  (an in   ddl  ddl) p18 w=w1 	l=l1
	MN1  (an in   gnd  gnd) n18 w=w1*2	l=l2

	MP2  (qn q   ddh  ddh) p33  w=w3 	l=l3
	MP3  (q  qn  ddh  ddh) p33  w=w3 	l=l3
	MN2  (net1 in  gnd  gnd ) n18 w=w4 	l=l4
	MN3  (net2  an  gnd  gnd ) n18 w=w4        l=l4
	MN5  (qn in  net1  gnd ) nnt33 w=w5 	l=l5
	MN6  (q  an  net2  gnd ) nnt33 w=w5        l=l5

	MP4  (out qn  ddh  ddh)  p33 w=w6 	l=l6
	MN4  (out qn  gnd  gnd)  n33 w=w6*2 	l=l7

ends level_shifter

save Xlevel_shifter:pwr
save Xlevel_shifter.MN1:vdsat Xlevel_shifter.MN1:region
save Xlevel_shifter.MN2:vdsat Xlevel_shifter.MN2:region
save Xlevel_shifter.MN3:vdsat Xlevel_shifter.MN3:region
save Xlevel_shifter.MN4:vdsat Xlevel_shifter.MN4:region
save Xlevel_shifter.MN5:vdsat Xlevel_shifter.MN5:region
save Xlevel_shifter.MN6:vdsat Xlevel_shifter.MN6:region

save Xlevel_shifter.MP1:vdsat Xlevel_shifter.MP1:region
save Xlevel_shifter.MP2:vdsat Xlevel_shifter.MP2:region
save Xlevel_shifter.MP3:vdsat Xlevel_shifter.MP3:region
save Xlevel_shifter.MP4:vdsat Xlevel_shifter.MP4:region
save Xlevel_shifter.MP5:vdsat Xlevel_shifter.MP5:region
save Xlevel_shifter.MP6:vdsat Xlevel_shifter.MP6:region
