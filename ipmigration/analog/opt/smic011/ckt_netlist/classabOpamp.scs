//*include "/home/shunqidai/Sizing/SizingDemoLinuxSpectre/smic018/models/spectre/ms018_v1p7_spe.lib" section=tt

parameters vdd=3.3 cload=5pf

subckt diff_opamp dd gnd inp inn netib out
// replace w8, l8, l2, l3 with w3, l1 modify w2 to 2*w3
	M301  (net2 inn   net1 net1) p33 w=w1 	l=l1
	M303  (net3 inp   net1 net1) p33 w=w1 	l=l1
	M321  (net1 net7  dd   dd  ) p33 w=2*w3 	l=l1
	M239  (net5 net7  dd   dd  ) p33 w=w3 	l=l1
	M204  (net8 net7  dd   dd  ) p33 w=2*w3 	l=l1
	M206  (net11 net7  dd   dd  ) p33 w=2*w3 	l=l1

	M218  (net6 net6  dd   dd  ) p33 w=w4 	l=l4
	M200  (net4 net6  net8 dd  ) p33 w=w5 	l=l5
	M202  (net9 net6  net11   dd  ) p33 w=w5*0.5 l=l5
	M2021 (net10 net6 net11   dd  ) p33 w=w5*0.5 l=l5

	M219  (net5 net5  gnd  gnd  ) n33 w=w6 	l=l6
	M201  (net4 net5  net2 gnd  ) n33 w=w7 	l=l7
	M203  (net9 net5  net3 gnd  ) n33 w=w7*0.5 l=l7
	M2031 (net10 net12 net3   gnd  ) n33 w=w7*0.5 l=l7
	M238  (net6 netib  gnd  gnd ) n33 w=w3 	l=l3
	M205  (net2 net4  gnd  gnd ) n33 w=w9 	l=l9
	M207  (net3 net4  gnd  gnd ) n33 w=w9 	l=l9

	M115  (net14 net15  dd   dd  ) p33 w=w10 	l=l10
	M113  (net15 net15  dd   dd  ) p33 w=w10 	l=l10
	M110  (net12 net9 net14   dd  ) p33 w=w10 	l=l10

	M100  (out  net9  dd   dd  ) p33 w=w11 	l=l11
	M101  (out  net10  gnd  gnd ) n33 w=w12 	l=l12

	M111  (net15 net10 gnd gnd  ) n33 w=w13 	l=l13
	M112  (net12 net12 gnd  gnd  ) n33 w=w6*0.5 	l=l6
	M500  (net7 net7  dd   dd  ) p33 w=w3 	l=l3
	M501  (net7 netib  gnd  gnd ) n33 w=w3 	l=l3
	M502  (netib netib  gnd  gnd ) n33 w=w3 l=l3

	cm1a  (net9 out)  capacitor  c=cc
	cm1b  (net10 out)  capacitor  c=cc
ends diff_opamp
