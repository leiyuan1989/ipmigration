// Comparator Characterization Testbench
// Transient offset
simulator lang=spectre
global 0

// include model card
include "/home/shunqidai/Sizing/SizingDemoLinuxSpectre_integer_stdcell/smic011/models/spectre/ms011_ms013s_io33_v1p24_spe.lib" section=tt

// define w/l
parameters w1 = 14.7  l1 = 0.2    w3 = 1.5 l3 = 0.2  w4 = 2.8  l4 = 0.2	   w5 = 2.9  l5 = 0.2 w6 = 1.9  l6 = 0.2  w7 = 3.6  l7 = 0.2 w8 = 12.6  l8 = 0.2

// define vref
parameters vref=0.6

// Include the circuit
include    "/home/shunqidai/Sizing/SizingDemoLinuxSpectre_integer_stdcell/smic011/ckt_netlist/dynamicComparator.scs"

// the power supply 1.2 V and current bias
vdd    (dd  0)   vsource  dc=vdd     type=dc

// the input signal for dc and tran simulation
vin    (inn 0)      vsource  dc=vref    type=dc
vip    (inp 0)     vsource  type=pwl	   wave=[0 0.595 0.5u 0.595 1.5u 0.605]
vclk  (clk 0)      vsource type=pulse	val0=0 val1=vdd delay=0.5u rise=1n fall=1n width=25n period=50n

clp   (outp 0) 	capacitor  c=cload
cln   (outn 0) 	capacitor  c=cload

// the circuit
Xcomp (dd 0 inp inn clk outp outn)  dynamic_comp

// Sprctre Analyses and Output Options
// Output Options
simulatorOptions options
+    reltol=1e-3 vabstol=1e-6 iabstol=1e-12 temp=27
+    tnom=27 scalem=1.0 scale=1.0e-6 gmin=1e-12 rforce=1 maxnotes=5 maxwarns=5
+    digits=5 cols=80 pivrel=1e-3 sensfile="../psf/sens.output"
+    checklimitdest=psf

// Analyses
outtran1 tran start=0.0 stop=1.5e-6 annotate=status
saveOptions options save=allpub subcktprobelvl=2

// minstep=1e-13 maxstep=1e-10

// end of file
