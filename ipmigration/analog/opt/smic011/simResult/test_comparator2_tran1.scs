// Comparator Characterization Testbench
// Transient offset
simulator lang=spectre
global 0

// include model card
include "/home/shunqidai/Sizing/SizingDemoLinuxSpectre_integer_stdcell/smic011/models/spectre/ms011_ms013s_io33_v1p24_spe.lib" section=tt

// define w/l
parameters w1 = 19.4  l1 = 0.5  w2 = 8.6  l2 = 0.5  w3 = 3.8 l3 = 0.5  w4 = 12.7  l4 = 0.5	   w5 = 24.9  l5 = 0.5 w6 = 12.8  l6 = 0.5

// define bias current
parameters ib=2u

// define vref
parameters vref=1.65

// Include the circuit
include    "/home/shunqidai/Sizing/SizingDemoLinuxSpectre_integer_stdcell/smic011/ckt_netlist/comparator1.scs"

// the power supply 1.8 V and current bias
vdd    (dd  0)   vsource  dc=vdd     type=dc
ibias  (dd ibias) isource  dc=ib    type=dc

// the input signal for dc and tran simulation
vin    (inn 0)      vsource  dc=vref    type=dc
//vip    (inp 0)     vsource  type=pwl	   wave=[0 1.64 0.5u 1.64 1.5u 1.66 2.5u 1.64  3.0u 1.64]

vip    (inp 0)     vsource  type=pwl	   wave=[0 1.55 1u 1.55 1.001m 1.75 2.001m 1.55  2.002m 1.55]

clp   (out 0) 	capacitor  c=cload

// the circuit
Xcomp (dd 0 inp inn out ibias)  comp

// Sprctre Analyses and Output Options
// Output Options
simulatorOptions options
+    reltol=1e-3 vabstol=1e-6 iabstol=1e-12 temp=27
+    tnom=27 scalem=1.0 scale=1.0e-6 gmin=1e-12 rforce=1 maxnotes=5 maxwarns=5
+    digits=5 cols=80 pivrel=1e-3 sensfile="../psf/sens.output"
+    checklimitdest=psf

// Analyses
outtran1 tran start=0.0 stop=2.002e-3 annotate=status
saveOptions options save=allpub subcktprobelvl=2

// minstep=1e-13 maxstep=1e-10

// end of file
