ADE simulation setup
Test Two_Stage_Opamp:OpAmp_TRAN_top:1: Two_Stage_Opamp/OpAmp_TRAN_top/schematic, simulator spectre
  Models: ./gpdk045_v_3_5/models/spectre/gpdk045.scs[mc]
  Variables: cload = 1p; rload = 1K; M6_l = 900n; M6_fw = 8u; M6_fingers = 2; M5_l = 280n; M5_fw = 1.6e-05; M5_fingers = 32; M3_l = 1.76u; M3_fw = 11u; M3_fingers = 8; M1_l = 1.48u; temp1 = 27; M1_fw = 20u; M1_fingers = 20; M10_l = 700n; M10_fw = 12u; M10_fingers = 10; C0_w = 2.1155e-05; C0_m = 16; C0_c = 600f; vdd = 1.8; sim_time = 1e-07; cont = 2.5; rend = 0; R0_r = 500; M9_M10_fingers_ratio = 4; M8_M6_fingers_ratio = 5; M7_M6_fingers_ratio = 3
  Temperature: 27
  Analysis dc: (saves the operating point)
  Analysis tran: stop=30n errpreset=conservative
  Output SettlingTime = settlingTime(VT("/OUT") -0.825 nil 0.825 nil 10)
  Output Swing = (value(VT("/OUT") 2.5e-08) - value(VT("/OUT") 1e-09))
  Signals: /OUT
