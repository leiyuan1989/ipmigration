ADE simulation setup
Device parameters:
  Two_Stage_Opamp/OpAmp/schematic/M1.fw = 5u
  Two_Stage_Opamp/OpAmp/schematic/M1.l = 1u
  Two_Stage_Opamp/OpAmp/schematic/M10.fw = 6u
  Two_Stage_Opamp/OpAmp/schematic/M10.l = 3u
  Two_Stage_Opamp/OpAmp/schematic/M3.fw = 5.5u
  Two_Stage_Opamp/OpAmp/schematic/M3.l = 700n
  Two_Stage_Opamp/OpAmp/schematic/M6.fw = 7.5u
  Two_Stage_Opamp/OpAmp/schematic/M6.l = 450n
  Two_Stage_Opamp/OpAmp/schematic/M5.fw = 9u
  Two_Stage_Opamp/OpAmp/schematic/M5.l = 1u
