// Differential Operational Amplifier Characterization Testbench
simulator lang=spectre
global 0

// include model card
include "/home/shunqidai/Sizing/SizingDemoLinuxSpectre_integer_stdcell/smic40/models/spectre/l0040ll_v1p4_1r_spe.lib" section=tt

parameters w1 = 9.6  l1 = 1.0 w2 = 38.6 l2 = 2.0  w3 = 48.6 l3 = 2.0  w4 = 64.0  l4 = 2.0	w5 = 73.2  l5 = 2.0   cc=1.1e-12   cr=92900.0 ib=1e-05

// Include the circuit
include    "/home/shunqidai/Sizing/SizingDemoLinuxSpectre_integer_stdcell/smic40/ckt_netlist/twoStageOpamp2.scs"

parameters v_in=0
// the power supply 3.3 V and current bias
vdd    (dd  0)   vsource  dc=vdd     type=dc
ibias  (dd net7) isource  dc=ib    type=dc

// the input signal for dc and tran simulation
vip    (inp  0)     vsource  dc=vdd/2    type=dc
vin    (in  0)      vsource  dc=v_in    type=dc

// the circuit
Xopamp (dd 0 inp inn net7 out)  diff_opamp
cl 	   (out 0) 					capacitor  c=cload
r1     (in    inn) 				resistor   r=10000k
rf     (inn    out) 			resistor   r=100000k

// Sprctre Analyses and Output Options
// Output Options
simulatorOptions options
+    reltol=1e-3 vabstol=1e-6 iabstol=1e-12 temp=27
+    tnom=27 scalem=1.0 scale=1.0e-6 gmin=1e-12 rforce=1 maxnotes=5 maxwarns=5
+    digits=5 cols=80 pivrel=1e-3 sensfile="../psf/sens.output"
+    checklimitdest=psf

// Analyses
outdc2 dc param=v_in start=0.0 stop=vdd step=10e-3 annotate=status
saveOptions options save=allpub subcktprobelvl=2

// end of file
