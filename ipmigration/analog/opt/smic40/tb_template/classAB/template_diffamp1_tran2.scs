// Differential Operational Amplifier Characterization Testbench
// Transient Negative Slewrate
simulator lang=spectre
global 0

// include model card
include "dummy_model_card_path" section=dummy_corner_name

// no w8, w2, l8, l2, l3 fixed w3=3.0, L:10, W:10
parameters w1 = {w1}  l1 = {l1}  w3 = {w3} l3 = {l3}    w4 = {w4}  l4 = {l4}	w5 = {w5}  l5 = {l5}  w6 = {w6}  l6 = {l6}  w7 = {w7}  l7 = {l7}   w9 = {w9}  l9 = {l9}  w10 = {w10}  l10 = {l10}  w11 = {w11}  l11 = {l11}   w12 = {w12}  l12 = {l12}  w13 = {w13}  l13 = {l13}    cc={cc}

// Include the circuit
include    "/home/shunqidai/Sizing/SizingDemoLinuxSpectre_integer_stdcell/smic018/ckt_netlist/classabOpamp.scs"

// the power supply 3.3 V and current bias
vdd    (dd  0)   vsource  dc=vdd     type=dc
ibias  (dd net7) isource  dc={ib}    type=dc

// the input signal for dc and tran simulation
vcm    (net8 0)       vsource  dc=vdd/2    type=dc
vip    (inp net8)     vsource  type=pwl	   wave=[0 0 10n 0 11n -200m 20n -200m]

// the circuit
Xopamp (dd 0 inp out net7 out)  diff_opamp
cl 	   (out 0) 					capacitor  c=cload

// Sprctre Analyses and Output Options
// Output Options
simulatorOptions options
+    reltol=1e-3 vabstol=1e-6 iabstol=1e-12 temp=27
+    tnom=27 scalem=1.0 scale=1.0e-6 gmin=1e-12 rforce=1 maxnotes=5 maxwarns=5
+    digits=5 cols=80 pivrel=1e-3 sensfile="../psf/sens.output"
+    checklimitdest=psf

// Analyses
old_data_output_filename tran start=0.0 stop=1000e-9  annotate=status
saveOptions options save=allpub subcktprobelvl=2

//minstep=1e-13 maxstep=1e-10
// end of file
