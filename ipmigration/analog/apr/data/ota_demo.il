cvid = dbOpenCellViewByType("ipm_demo_amp2" "ota_demo" "layout" "maskLayout" "w")
masterpmos = dbOpenCellViewByType( "tsmc18rf" "pmos3v" "layout" "maskLayout" "r")
masternmos = dbOpenCellViewByType( "tsmc18rf" "nmos3v" "layout" "maskLayout" "r")
masterres = dbOpenCellViewByType( "tsmc18rf" "rnhpoly" "layout" "maskLayout" "r")
mastercap = dbOpenCellViewByType( "tsmc18rf" "mimcap" "layout" "maskLayout" "r")
dbCreateParamInst(cvid masterpmos "I0" list(2.580 56.170) "R0" 1 list(list("w" "string" "21.00u") list("l" "string" "2.00u") ))
dbCreateParamInst(cvid masterpmos "M20.1" list(5.120 56.170) "R0" 1 list(list("w" "string" "21.00u") list("l" "string" "2.00u") ))
dbCreateParamInst(cvid masterpmos "M20.2" list(9.660 56.170) "MY" 1 list(list("w" "string" "21.00u") list("l" "string" "2.00u") ))
dbCreateParamInst(cvid masterpmos "M20.3" list(10.200 56.170) "R0" 1 list(list("w" "string" "21.00u") list("l" "string" "2.00u") ))
dbCreateParamInst(cvid masterpmos "M20.4" list(14.740 56.170) "MY" 1 list(list("w" "string" "21.00u") list("l" "string" "2.00u") ))
dbCreateParamInst(cvid masterpmos "M20.5" list(15.280 56.170) "R0" 1 list(list("w" "string" "21.00u") list("l" "string" "2.00u") ))
dbCreateParamInst(cvid masterpmos "M20.6" list(19.820 56.170) "MY" 1 list(list("w" "string" "21.00u") list("l" "string" "2.00u") ))
dbCreateParamInst(cvid masterpmos "M20.7" list(20.360 56.170) "R0" 1 list(list("w" "string" "21.00u") list("l" "string" "2.00u") ))
dbCreateParamInst(cvid masterpmos "M20.8" list(24.900 56.170) "MY" 1 list(list("w" "string" "21.00u") list("l" "string" "2.00u") ))
dbCreateParamInst(cvid masterpmos "M19.1" list(25.440 56.170) "R0" 1 list(list("w" "string" "21.00u") list("l" "string" "2.00u") ))
dbCreateParamInst(cvid masterpmos "M19.2" list(29.980 56.170) "MY" 1 list(list("w" "string" "21.00u") list("l" "string" "2.00u") ))
dbCreateParamInst(cvid masterpmos "M19.3" list(30.520 56.170) "R0" 1 list(list("w" "string" "21.00u") list("l" "string" "2.00u") ))
dbCreateParamInst(cvid masterpmos "M19.4" list(35.060 56.170) "MY" 1 list(list("w" "string" "21.00u") list("l" "string" "2.00u") ))
dbCreateParamInst(cvid masterpmos "M21.1" list(35.600 56.170) "R0" 1 list(list("w" "string" "21.00u") list("l" "string" "2.00u") ))
dbCreateParamInst(cvid masterpmos "M21.2" list(40.140 56.170) "MY" 1 list(list("w" "string" "21.00u") list("l" "string" "2.00u") ))
dbCreateParamInst(cvid masterpmos "M21.3" list(40.680 56.170) "R0" 1 list(list("w" "string" "21.00u") list("l" "string" "2.00u") ))
dbCreateParamInst(cvid masterpmos "M21.4" list(45.220 56.170) "MY" 1 list(list("w" "string" "21.00u") list("l" "string" "2.00u") ))
dbCreateParamInst(cvid masterpmos "M21.5" list(45.760 56.170) "R0" 1 list(list("w" "string" "21.00u") list("l" "string" "2.00u") ))
dbCreateParamInst(cvid masterpmos "M21.6" list(50.300 56.170) "MY" 1 list(list("w" "string" "21.00u") list("l" "string" "2.00u") ))
dbCreateParamInst(cvid masterpmos "M21.7" list(50.840 56.170) "R0" 1 list(list("w" "string" "21.00u") list("l" "string" "2.00u") ))
dbCreateParamInst(cvid masterpmos "M21.8" list(55.380 56.170) "MY" 1 list(list("w" "string" "21.00u") list("l" "string" "2.00u") ))
dbCreateParamInst(cvid masterpmos "M21.9" list(55.920 56.170) "R0" 1 list(list("w" "string" "21.00u") list("l" "string" "2.00u") ))
dbCreateParamInst(cvid masterpmos "M21.10" list(60.460 56.170) "MY" 1 list(list("w" "string" "21.00u") list("l" "string" "2.00u") ))
dbCreateParamInst(cvid masterpmos "M21.11" list(61.000 56.170) "R0" 1 list(list("w" "string" "21.00u") list("l" "string" "2.00u") ))
dbCreateParamInst(cvid masterpmos "M21.12" list(65.540 56.170) "MY" 1 list(list("w" "string" "21.00u") list("l" "string" "2.00u") ))
dbCreateParamInst(cvid masterpmos "M21.13" list(66.080 56.170) "R0" 1 list(list("w" "string" "21.00u") list("l" "string" "2.00u") ))
dbCreateParamInst(cvid masterpmos "M21.14" list(70.620 56.170) "MY" 1 list(list("w" "string" "21.00u") list("l" "string" "2.00u") ))
dbCreateParamInst(cvid masterpmos "M21.15" list(71.160 56.170) "R0" 1 list(list("w" "string" "21.00u") list("l" "string" "2.00u") ))
dbCreateParamInst(cvid masterpmos "M21.16" list(75.700 56.170) "MY" 1 list(list("w" "string" "21.00u") list("l" "string" "2.00u") ))
dbCreateParamInst(cvid masterpmos "I1" list(78.240 56.170) "MY" 1 list(list("w" "string" "21.00u") list("l" "string" "2.00u") ))
dbCreateRect(cvid list("METAL1" "drawing") list(2.11:56.17 2.51:77.17))
dbCreateRect(cvid list("METAL1" "drawing") list(4.65:56.17 5.05:77.17))
dbCreateRect(cvid list("METAL1" "drawing") list(7.19:56.17 7.59:77.17))
dbCreateRect(cvid list("METAL1" "drawing") list(9.73:56.17 10.13:77.17))
dbCreateRect(cvid list("METAL1" "drawing") list(12.27:56.17 12.67:77.17))
dbCreateRect(cvid list("METAL1" "drawing") list(14.81:56.17 15.21:77.17))
dbCreateRect(cvid list("METAL1" "drawing") list(17.35:56.17 17.75:77.17))
dbCreateRect(cvid list("METAL1" "drawing") list(19.89:56.17 20.29:77.17))
dbCreateRect(cvid list("METAL1" "drawing") list(22.43:56.17 22.83:77.17))
dbCreateRect(cvid list("METAL1" "drawing") list(24.97:56.17 25.37:77.17))
dbCreateRect(cvid list("METAL1" "drawing") list(27.51:56.17 27.91:77.17))
dbCreateRect(cvid list("METAL1" "drawing") list(30.05:56.17 30.45:77.17))
dbCreateRect(cvid list("METAL1" "drawing") list(32.59:56.17 32.99:77.17))
dbCreateRect(cvid list("METAL1" "drawing") list(35.13:56.17 35.53:77.17))
dbCreateRect(cvid list("METAL1" "drawing") list(37.67:56.17 38.07:77.17))
dbCreateRect(cvid list("METAL1" "drawing") list(40.21:56.17 40.61:77.17))
dbCreateRect(cvid list("METAL1" "drawing") list(42.75:56.17 43.15:77.17))
dbCreateRect(cvid list("METAL1" "drawing") list(45.29:56.17 45.69:77.17))
dbCreateRect(cvid list("METAL1" "drawing") list(47.83:56.17 48.23:77.17))
dbCreateRect(cvid list("METAL1" "drawing") list(50.37:56.17 50.77:77.17))
dbCreateRect(cvid list("METAL1" "drawing") list(52.91:56.17 53.31:77.17))
dbCreateRect(cvid list("METAL1" "drawing") list(55.45:56.17 55.85:77.17))
dbCreateRect(cvid list("METAL1" "drawing") list(57.99:56.17 58.39:77.17))
dbCreateRect(cvid list("METAL1" "drawing") list(60.53:56.17 60.93:77.17))
dbCreateRect(cvid list("METAL1" "drawing") list(63.07:56.17 63.47:77.17))
dbCreateRect(cvid list("METAL1" "drawing") list(65.61:56.17 66.01:77.17))
dbCreateRect(cvid list("METAL1" "drawing") list(68.15:56.17 68.55:77.17))
dbCreateRect(cvid list("METAL1" "drawing") list(70.69:56.17 71.09:77.17))
dbCreateRect(cvid list("METAL1" "drawing") list(73.23:56.17 73.63:77.17))
dbCreateRect(cvid list("METAL1" "drawing") list(75.77:56.17 76.17:77.17))
dbCreateRect(cvid list("METAL1" "drawing") list(78.31:56.17 78.71:77.17))
dbCreateRect(cvid list("POLY1" "drawing") list(2.58:55.53 4.58:55.95))
dbCreateRect(cvid list("METAL1" "drawing") list(2.70:55.53 4.45:55.95))
dbCreateRect(cvid list("CONT" "drawing") list(3.00:55.63 3.22:55.85))
dbCreateRect(cvid list("CONT" "drawing") list(3.47:55.63 3.69:55.85))
dbCreateRect(cvid list("CONT" "drawing") list(3.94:55.63 4.16:55.85))
dbCreateRect(cvid list("POLY1" "drawing") list(5.12:55.53 7.12:55.95))
dbCreateRect(cvid list("METAL1" "drawing") list(5.24:55.53 6.99:55.95))
dbCreateRect(cvid list("CONT" "drawing") list(5.54:55.63 5.76:55.85))
dbCreateRect(cvid list("CONT" "drawing") list(6.01:55.63 6.23:55.85))
dbCreateRect(cvid list("CONT" "drawing") list(6.48:55.63 6.70:55.85))
dbCreateRect(cvid list("POLY1" "drawing") list(7.66:55.53 9.66:55.95))
dbCreateRect(cvid list("METAL1" "drawing") list(7.78:55.53 9.53:55.95))
dbCreateRect(cvid list("CONT" "drawing") list(8.08:55.63 8.30:55.85))
dbCreateRect(cvid list("CONT" "drawing") list(8.55:55.63 8.77:55.85))
dbCreateRect(cvid list("CONT" "drawing") list(9.02:55.63 9.24:55.85))
dbCreateRect(cvid list("POLY1" "drawing") list(10.20:55.53 12.20:55.95))
dbCreateRect(cvid list("METAL1" "drawing") list(10.32:55.53 12.07:55.95))
dbCreateRect(cvid list("CONT" "drawing") list(10.62:55.63 10.84:55.85))
dbCreateRect(cvid list("CONT" "drawing") list(11.09:55.63 11.31:55.85))
dbCreateRect(cvid list("CONT" "drawing") list(11.56:55.63 11.78:55.85))
dbCreateRect(cvid list("POLY1" "drawing") list(12.74:55.53 14.74:55.95))
dbCreateRect(cvid list("METAL1" "drawing") list(12.86:55.53 14.61:55.95))
dbCreateRect(cvid list("CONT" "drawing") list(13.16:55.63 13.38:55.85))
dbCreateRect(cvid list("CONT" "drawing") list(13.63:55.63 13.85:55.85))
dbCreateRect(cvid list("CONT" "drawing") list(14.10:55.63 14.32:55.85))
dbCreateRect(cvid list("POLY1" "drawing") list(15.28:55.53 17.28:55.95))
dbCreateRect(cvid list("METAL1" "drawing") list(15.40:55.53 17.15:55.95))
dbCreateRect(cvid list("CONT" "drawing") list(15.70:55.63 15.92:55.85))
dbCreateRect(cvid list("CONT" "drawing") list(16.17:55.63 16.39:55.85))
dbCreateRect(cvid list("CONT" "drawing") list(16.64:55.63 16.86:55.85))
dbCreateRect(cvid list("POLY1" "drawing") list(17.82:55.53 19.82:55.95))
dbCreateRect(cvid list("METAL1" "drawing") list(17.94:55.53 19.69:55.95))
dbCreateRect(cvid list("CONT" "drawing") list(18.24:55.63 18.46:55.85))
dbCreateRect(cvid list("CONT" "drawing") list(18.71:55.63 18.93:55.85))
dbCreateRect(cvid list("CONT" "drawing") list(19.18:55.63 19.40:55.85))
dbCreateRect(cvid list("POLY1" "drawing") list(20.36:55.53 22.36:55.95))
dbCreateRect(cvid list("METAL1" "drawing") list(20.48:55.53 22.23:55.95))
dbCreateRect(cvid list("CONT" "drawing") list(20.78:55.63 21.00:55.85))
dbCreateRect(cvid list("CONT" "drawing") list(21.25:55.63 21.47:55.85))
dbCreateRect(cvid list("CONT" "drawing") list(21.72:55.63 21.94:55.85))
dbCreateRect(cvid list("POLY1" "drawing") list(22.90:55.53 24.90:55.95))
dbCreateRect(cvid list("METAL1" "drawing") list(23.02:55.53 24.77:55.95))
dbCreateRect(cvid list("CONT" "drawing") list(23.32:55.63 23.54:55.85))
dbCreateRect(cvid list("CONT" "drawing") list(23.79:55.63 24.01:55.85))
dbCreateRect(cvid list("CONT" "drawing") list(24.26:55.63 24.48:55.85))
dbCreateRect(cvid list("POLY1" "drawing") list(25.44:55.53 27.44:55.95))
dbCreateRect(cvid list("METAL1" "drawing") list(25.56:55.53 27.31:55.95))
dbCreateRect(cvid list("CONT" "drawing") list(25.86:55.63 26.08:55.85))
dbCreateRect(cvid list("CONT" "drawing") list(26.33:55.63 26.55:55.85))
dbCreateRect(cvid list("CONT" "drawing") list(26.80:55.63 27.02:55.85))
dbCreateRect(cvid list("POLY1" "drawing") list(27.98:55.53 29.98:55.95))
dbCreateRect(cvid list("METAL1" "drawing") list(28.10:55.53 29.85:55.95))
dbCreateRect(cvid list("CONT" "drawing") list(28.40:55.63 28.62:55.85))
dbCreateRect(cvid list("CONT" "drawing") list(28.87:55.63 29.09:55.85))
dbCreateRect(cvid list("CONT" "drawing") list(29.34:55.63 29.56:55.85))
dbCreateRect(cvid list("POLY1" "drawing") list(30.52:55.53 32.52:55.95))
dbCreateRect(cvid list("METAL1" "drawing") list(30.64:55.53 32.39:55.95))
dbCreateRect(cvid list("CONT" "drawing") list(30.94:55.63 31.16:55.85))
dbCreateRect(cvid list("CONT" "drawing") list(31.41:55.63 31.63:55.85))
dbCreateRect(cvid list("CONT" "drawing") list(31.88:55.63 32.10:55.85))
dbCreateRect(cvid list("POLY1" "drawing") list(33.06:55.53 35.06:55.95))
dbCreateRect(cvid list("METAL1" "drawing") list(33.18:55.53 34.93:55.95))
dbCreateRect(cvid list("CONT" "drawing") list(33.48:55.63 33.70:55.85))
dbCreateRect(cvid list("CONT" "drawing") list(33.95:55.63 34.17:55.85))
dbCreateRect(cvid list("CONT" "drawing") list(34.42:55.63 34.64:55.85))
dbCreateRect(cvid list("POLY1" "drawing") list(35.60:55.53 37.60:55.95))
dbCreateRect(cvid list("METAL1" "drawing") list(35.72:55.53 37.47:55.95))
dbCreateRect(cvid list("CONT" "drawing") list(36.02:55.63 36.24:55.85))
dbCreateRect(cvid list("CONT" "drawing") list(36.49:55.63 36.71:55.85))
dbCreateRect(cvid list("CONT" "drawing") list(36.96:55.63 37.18:55.85))
dbCreateRect(cvid list("POLY1" "drawing") list(38.14:55.53 40.14:55.95))
dbCreateRect(cvid list("METAL1" "drawing") list(38.26:55.53 40.01:55.95))
dbCreateRect(cvid list("CONT" "drawing") list(38.56:55.63 38.78:55.85))
dbCreateRect(cvid list("CONT" "drawing") list(39.03:55.63 39.25:55.85))
dbCreateRect(cvid list("CONT" "drawing") list(39.50:55.63 39.72:55.85))
dbCreateRect(cvid list("POLY1" "drawing") list(40.68:55.53 42.68:55.95))
dbCreateRect(cvid list("METAL1" "drawing") list(40.80:55.53 42.55:55.95))
dbCreateRect(cvid list("CONT" "drawing") list(41.10:55.63 41.32:55.85))
dbCreateRect(cvid list("CONT" "drawing") list(41.57:55.63 41.79:55.85))
dbCreateRect(cvid list("CONT" "drawing") list(42.04:55.63 42.26:55.85))
dbCreateRect(cvid list("POLY1" "drawing") list(43.22:55.53 45.22:55.95))
dbCreateRect(cvid list("METAL1" "drawing") list(43.34:55.53 45.09:55.95))
dbCreateRect(cvid list("CONT" "drawing") list(43.64:55.63 43.86:55.85))
dbCreateRect(cvid list("CONT" "drawing") list(44.11:55.63 44.33:55.85))
dbCreateRect(cvid list("CONT" "drawing") list(44.58:55.63 44.80:55.85))
dbCreateRect(cvid list("POLY1" "drawing") list(45.76:55.53 47.76:55.95))
dbCreateRect(cvid list("METAL1" "drawing") list(45.88:55.53 47.63:55.95))
dbCreateRect(cvid list("CONT" "drawing") list(46.18:55.63 46.40:55.85))
dbCreateRect(cvid list("CONT" "drawing") list(46.65:55.63 46.87:55.85))
dbCreateRect(cvid list("CONT" "drawing") list(47.12:55.63 47.34:55.85))
dbCreateRect(cvid list("POLY1" "drawing") list(48.30:55.53 50.30:55.95))
dbCreateRect(cvid list("METAL1" "drawing") list(48.42:55.53 50.17:55.95))
dbCreateRect(cvid list("CONT" "drawing") list(48.72:55.63 48.94:55.85))
dbCreateRect(cvid list("CONT" "drawing") list(49.19:55.63 49.41:55.85))
dbCreateRect(cvid list("CONT" "drawing") list(49.66:55.63 49.88:55.85))
dbCreateRect(cvid list("POLY1" "drawing") list(50.84:55.53 52.84:55.95))
dbCreateRect(cvid list("METAL1" "drawing") list(50.96:55.53 52.71:55.95))
dbCreateRect(cvid list("CONT" "drawing") list(51.26:55.63 51.48:55.85))
dbCreateRect(cvid list("CONT" "drawing") list(51.73:55.63 51.95:55.85))
dbCreateRect(cvid list("CONT" "drawing") list(52.20:55.63 52.42:55.85))
dbCreateRect(cvid list("POLY1" "drawing") list(53.38:55.53 55.38:55.95))
dbCreateRect(cvid list("METAL1" "drawing") list(53.50:55.53 55.25:55.95))
dbCreateRect(cvid list("CONT" "drawing") list(53.80:55.63 54.02:55.85))
dbCreateRect(cvid list("CONT" "drawing") list(54.27:55.63 54.49:55.85))
dbCreateRect(cvid list("CONT" "drawing") list(54.74:55.63 54.96:55.85))
dbCreateRect(cvid list("POLY1" "drawing") list(55.92:55.53 57.92:55.95))
dbCreateRect(cvid list("METAL1" "drawing") list(56.04:55.53 57.79:55.95))
dbCreateRect(cvid list("CONT" "drawing") list(56.34:55.63 56.56:55.85))
dbCreateRect(cvid list("CONT" "drawing") list(56.81:55.63 57.03:55.85))
dbCreateRect(cvid list("CONT" "drawing") list(57.28:55.63 57.50:55.85))
dbCreateRect(cvid list("POLY1" "drawing") list(58.46:55.53 60.46:55.95))
dbCreateRect(cvid list("METAL1" "drawing") list(58.58:55.53 60.33:55.95))
dbCreateRect(cvid list("CONT" "drawing") list(58.88:55.63 59.10:55.85))
dbCreateRect(cvid list("CONT" "drawing") list(59.35:55.63 59.57:55.85))
dbCreateRect(cvid list("CONT" "drawing") list(59.82:55.63 60.04:55.85))
dbCreateRect(cvid list("POLY1" "drawing") list(61.00:55.53 63.00:55.95))
dbCreateRect(cvid list("METAL1" "drawing") list(61.12:55.53 62.87:55.95))
dbCreateRect(cvid list("CONT" "drawing") list(61.42:55.63 61.64:55.85))
dbCreateRect(cvid list("CONT" "drawing") list(61.89:55.63 62.11:55.85))
dbCreateRect(cvid list("CONT" "drawing") list(62.36:55.63 62.58:55.85))
dbCreateRect(cvid list("POLY1" "drawing") list(63.54:55.53 65.54:55.95))
dbCreateRect(cvid list("METAL1" "drawing") list(63.66:55.53 65.41:55.95))
dbCreateRect(cvid list("CONT" "drawing") list(63.96:55.63 64.18:55.85))
dbCreateRect(cvid list("CONT" "drawing") list(64.43:55.63 64.65:55.85))
dbCreateRect(cvid list("CONT" "drawing") list(64.90:55.63 65.12:55.85))
dbCreateRect(cvid list("POLY1" "drawing") list(66.08:55.53 68.08:55.95))
dbCreateRect(cvid list("METAL1" "drawing") list(66.20:55.53 67.95:55.95))
dbCreateRect(cvid list("CONT" "drawing") list(66.50:55.63 66.72:55.85))
dbCreateRect(cvid list("CONT" "drawing") list(66.97:55.63 67.19:55.85))
dbCreateRect(cvid list("CONT" "drawing") list(67.44:55.63 67.66:55.85))
dbCreateRect(cvid list("POLY1" "drawing") list(68.62:55.53 70.62:55.95))
dbCreateRect(cvid list("METAL1" "drawing") list(68.74:55.53 70.49:55.95))
dbCreateRect(cvid list("CONT" "drawing") list(69.04:55.63 69.26:55.85))
dbCreateRect(cvid list("CONT" "drawing") list(69.51:55.63 69.73:55.85))
dbCreateRect(cvid list("CONT" "drawing") list(69.98:55.63 70.20:55.85))
dbCreateRect(cvid list("POLY1" "drawing") list(71.16:55.53 73.16:55.95))
dbCreateRect(cvid list("METAL1" "drawing") list(71.28:55.53 73.03:55.95))
dbCreateRect(cvid list("CONT" "drawing") list(71.58:55.63 71.80:55.85))
dbCreateRect(cvid list("CONT" "drawing") list(72.05:55.63 72.27:55.85))
dbCreateRect(cvid list("CONT" "drawing") list(72.52:55.63 72.74:55.85))
dbCreateRect(cvid list("POLY1" "drawing") list(73.70:55.53 75.70:55.95))
dbCreateRect(cvid list("METAL1" "drawing") list(73.83:55.53 75.58:55.95))
dbCreateRect(cvid list("CONT" "drawing") list(74.12:55.63 74.34:55.85))
dbCreateRect(cvid list("CONT" "drawing") list(74.59:55.63 74.81:55.85))
dbCreateRect(cvid list("CONT" "drawing") list(75.06:55.63 75.28:55.85))
dbCreateRect(cvid list("POLY1" "drawing") list(76.24:55.53 78.24:55.95))
dbCreateRect(cvid list("METAL1" "drawing") list(76.36:55.53 78.11:55.95))
dbCreateRect(cvid list("CONT" "drawing") list(76.66:55.63 76.88:55.85))
dbCreateRect(cvid list("CONT" "drawing") list(77.13:55.63 77.35:55.85))
dbCreateRect(cvid list("CONT" "drawing") list(77.60:55.63 77.82:55.85))
dbCreateRect(cvid list("DIFF" "drawing") list(0.93:54.79 1.39:55.25))
dbCreateRect(cvid list("METAL1" "drawing") list(0.93:54.79 1.39:55.25))
dbCreateRect(cvid list("CONT" "drawing") list(1.05:54.91 1.27:55.13))
dbCreateRect(cvid list("NIMP" "drawing") list(0.75:54.61 1.57:55.43))
dbCreateRect(cvid list("NWELL" "drawing") list(0.50:54.36 1.82:55.68))
dbCreateRect(cvid list("DIFF" "drawing") list(79.43:54.79 79.89:55.25))
dbCreateRect(cvid list("METAL1" "drawing") list(79.43:54.79 79.89:55.25))
dbCreateRect(cvid list("CONT" "drawing") list(79.55:54.91 79.77:55.13))
dbCreateRect(cvid list("NIMP" "drawing") list(79.25:54.61 80.07:55.43))
dbCreateRect(cvid list("NWELL" "drawing") list(79.00:54.36 80.32:55.68))
dbCreateRect(cvid list("DIFF" "drawing") list(0.93:77.88 1.39:78.34))
dbCreateRect(cvid list("METAL1" "drawing") list(0.93:77.88 1.39:78.34))
dbCreateRect(cvid list("CONT" "drawing") list(1.05:78.00 1.27:78.22))
dbCreateRect(cvid list("NIMP" "drawing") list(0.75:77.70 1.57:78.52))
dbCreateRect(cvid list("NWELL" "drawing") list(0.50:77.45 1.82:78.77))
dbCreateRect(cvid list("DIFF" "drawing") list(79.43:77.88 79.89:78.34))
dbCreateRect(cvid list("METAL1" "drawing") list(79.43:77.88 79.89:78.34))
dbCreateRect(cvid list("CONT" "drawing") list(79.55:78.00 79.77:78.22))
dbCreateRect(cvid list("NIMP" "drawing") list(79.25:77.70 80.07:78.52))
dbCreateRect(cvid list("NWELL" "drawing") list(79.00:77.45 80.32:78.77))
dbCreateRect(cvid list("DIFF" "drawing") list(0.93:55.25 1.39:77.88))
dbCreateRect(cvid list("METAL1" "drawing") list(0.93:55.25 1.39:77.88))
dbCreateRect(cvid list("CONT" "drawing") list(1.05:55.64 1.27:55.86))
dbCreateRect(cvid list("CONT" "drawing") list(1.05:56.11 1.27:56.33))
dbCreateRect(cvid list("CONT" "drawing") list(1.05:56.59 1.27:56.80))
dbCreateRect(cvid list("CONT" "drawing") list(1.05:57.05 1.27:57.27))
dbCreateRect(cvid list("CONT" "drawing") list(1.05:57.52 1.27:57.74))
dbCreateRect(cvid list("CONT" "drawing") list(1.05:57.99 1.27:58.21))
dbCreateRect(cvid list("CONT" "drawing") list(1.05:58.46 1.27:58.68))
dbCreateRect(cvid list("CONT" "drawing") list(1.05:58.94 1.27:59.16))
dbCreateRect(cvid list("CONT" "drawing") list(1.05:59.41 1.27:59.62))
dbCreateRect(cvid list("CONT" "drawing") list(1.05:59.88 1.27:60.09))
dbCreateRect(cvid list("CONT" "drawing") list(1.05:60.34 1.27:60.56))
dbCreateRect(cvid list("CONT" "drawing") list(1.05:60.81 1.27:61.03))
dbCreateRect(cvid list("CONT" "drawing") list(1.05:61.28 1.27:61.50))
dbCreateRect(cvid list("CONT" "drawing") list(1.05:61.75 1.27:61.97))
dbCreateRect(cvid list("CONT" "drawing") list(1.05:62.23 1.27:62.45))
dbCreateRect(cvid list("CONT" "drawing") list(1.05:62.70 1.27:62.91))
dbCreateRect(cvid list("CONT" "drawing") list(1.05:63.16 1.27:63.38))
dbCreateRect(cvid list("CONT" "drawing") list(1.05:63.63 1.27:63.85))
dbCreateRect(cvid list("CONT" "drawing") list(1.05:64.11 1.27:64.33))
dbCreateRect(cvid list("CONT" "drawing") list(1.05:64.58 1.27:64.80))
dbCreateRect(cvid list("CONT" "drawing") list(1.05:65.05 1.27:65.27))
dbCreateRect(cvid list("CONT" "drawing") list(1.05:65.52 1.27:65.73))
dbCreateRect(cvid list("CONT" "drawing") list(1.05:65.98 1.27:66.20))
dbCreateRect(cvid list("CONT" "drawing") list(1.05:66.45 1.27:66.67))
dbCreateRect(cvid list("CONT" "drawing") list(1.05:66.92 1.27:67.14))
dbCreateRect(cvid list("CONT" "drawing") list(1.05:67.39 1.27:67.61))
dbCreateRect(cvid list("CONT" "drawing") list(1.05:67.86 1.27:68.08))
dbCreateRect(cvid list("CONT" "drawing") list(1.05:68.33 1.27:68.55))
dbCreateRect(cvid list("CONT" "drawing") list(1.05:68.80 1.27:69.02))
dbCreateRect(cvid list("CONT" "drawing") list(1.05:69.27 1.27:69.49))
dbCreateRect(cvid list("CONT" "drawing") list(1.05:69.75 1.27:69.97))
dbCreateRect(cvid list("CONT" "drawing") list(1.05:70.22 1.27:70.44))
dbCreateRect(cvid list("CONT" "drawing") list(1.05:70.69 1.27:70.91))
dbCreateRect(cvid list("CONT" "drawing") list(1.05:71.16 1.27:71.38))
dbCreateRect(cvid list("CONT" "drawing") list(1.05:71.62 1.27:71.84))
dbCreateRect(cvid list("CONT" "drawing") list(1.05:72.09 1.27:72.31))
dbCreateRect(cvid list("CONT" "drawing") list(1.05:72.56 1.27:72.78))
dbCreateRect(cvid list("CONT" "drawing") list(1.05:73.03 1.27:73.25))
dbCreateRect(cvid list("CONT" "drawing") list(1.05:73.50 1.27:73.72))
dbCreateRect(cvid list("CONT" "drawing") list(1.05:73.97 1.27:74.19))
dbCreateRect(cvid list("CONT" "drawing") list(1.05:74.44 1.27:74.66))
dbCreateRect(cvid list("CONT" "drawing") list(1.05:74.91 1.27:75.13))
dbCreateRect(cvid list("CONT" "drawing") list(1.05:75.38 1.27:75.60))
dbCreateRect(cvid list("CONT" "drawing") list(1.05:75.85 1.27:76.07))
dbCreateRect(cvid list("CONT" "drawing") list(1.05:76.33 1.27:76.55))
dbCreateRect(cvid list("CONT" "drawing") list(1.05:76.80 1.27:77.02))
dbCreateRect(cvid list("CONT" "drawing") list(1.05:77.27 1.27:77.48))
dbCreateRect(cvid list("NIMP" "drawing") list(0.75:55.07 1.57:78.06))
dbCreateRect(cvid list("NWELL" "drawing") list(0.50:54.82 1.82:78.31))
dbCreateRect(cvid list("DIFF" "drawing") list(1.39:54.79 79.43:55.25))
dbCreateRect(cvid list("METAL1" "drawing") list(1.39:54.79 79.43:55.25))
dbCreateRect(cvid list("CONT" "drawing") list(1.76:54.91 1.98:55.13))
dbCreateRect(cvid list("CONT" "drawing") list(2.23:54.91 2.45:55.13))
dbCreateRect(cvid list("CONT" "drawing") list(2.70:54.91 2.92:55.13))
dbCreateRect(cvid list("CONT" "drawing") list(3.17:54.91 3.39:55.13))
dbCreateRect(cvid list("CONT" "drawing") list(3.64:54.91 3.86:55.13))
dbCreateRect(cvid list("CONT" "drawing") list(4.11:54.91 4.33:55.13))
dbCreateRect(cvid list("CONT" "drawing") list(4.58:54.91 4.80:55.13))
dbCreateRect(cvid list("CONT" "drawing") list(5.05:54.91 5.27:55.13))
dbCreateRect(cvid list("CONT" "drawing") list(5.52:54.91 5.74:55.13))
dbCreateRect(cvid list("CONT" "drawing") list(5.99:54.91 6.21:55.13))
dbCreateRect(cvid list("CONT" "drawing") list(6.46:54.91 6.68:55.13))
dbCreateRect(cvid list("CONT" "drawing") list(6.93:54.91 7.15:55.13))
dbCreateRect(cvid list("CONT" "drawing") list(7.40:54.91 7.62:55.13))
dbCreateRect(cvid list("CONT" "drawing") list(7.87:54.91 8.09:55.13))
dbCreateRect(cvid list("CONT" "drawing") list(8.34:54.91 8.56:55.13))
dbCreateRect(cvid list("CONT" "drawing") list(8.81:54.91 9.03:55.13))
dbCreateRect(cvid list("CONT" "drawing") list(9.28:54.91 9.50:55.13))
dbCreateRect(cvid list("CONT" "drawing") list(9.75:54.91 9.97:55.13))
dbCreateRect(cvid list("CONT" "drawing") list(10.22:54.91 10.44:55.13))
dbCreateRect(cvid list("CONT" "drawing") list(10.69:54.91 10.91:55.13))
dbCreateRect(cvid list("CONT" "drawing") list(11.16:54.91 11.38:55.13))
dbCreateRect(cvid list("CONT" "drawing") list(11.63:54.91 11.85:55.13))
dbCreateRect(cvid list("CONT" "drawing") list(12.10:54.91 12.32:55.13))
dbCreateRect(cvid list("CONT" "drawing") list(12.57:54.91 12.79:55.13))
dbCreateRect(cvid list("CONT" "drawing") list(13.04:54.91 13.26:55.13))
dbCreateRect(cvid list("CONT" "drawing") list(13.51:54.91 13.73:55.13))
dbCreateRect(cvid list("CONT" "drawing") list(13.98:54.91 14.20:55.13))
dbCreateRect(cvid list("CONT" "drawing") list(14.45:54.91 14.67:55.13))
dbCreateRect(cvid list("CONT" "drawing") list(14.92:54.91 15.14:55.13))
dbCreateRect(cvid list("CONT" "drawing") list(15.39:54.91 15.61:55.13))
dbCreateRect(cvid list("CONT" "drawing") list(15.86:54.91 16.08:55.13))
dbCreateRect(cvid list("CONT" "drawing") list(16.33:54.91 16.55:55.13))
dbCreateRect(cvid list("CONT" "drawing") list(16.80:54.91 17.02:55.13))
dbCreateRect(cvid list("CONT" "drawing") list(17.27:54.91 17.49:55.13))
dbCreateRect(cvid list("CONT" "drawing") list(17.74:54.91 17.96:55.13))
dbCreateRect(cvid list("CONT" "drawing") list(18.21:54.91 18.43:55.13))
dbCreateRect(cvid list("CONT" "drawing") list(18.68:54.91 18.90:55.13))
dbCreateRect(cvid list("CONT" "drawing") list(19.15:54.91 19.37:55.13))
dbCreateRect(cvid list("CONT" "drawing") list(19.62:54.91 19.84:55.13))
dbCreateRect(cvid list("CONT" "drawing") list(20.09:54.91 20.31:55.13))
dbCreateRect(cvid list("CONT" "drawing") list(20.56:54.91 20.78:55.13))
dbCreateRect(cvid list("CONT" "drawing") list(21.03:54.91 21.25:55.13))
dbCreateRect(cvid list("CONT" "drawing") list(21.50:54.91 21.72:55.13))
dbCreateRect(cvid list("CONT" "drawing") list(21.97:54.91 22.19:55.13))
dbCreateRect(cvid list("CONT" "drawing") list(22.44:54.91 22.66:55.13))
dbCreateRect(cvid list("CONT" "drawing") list(22.91:54.91 23.13:55.13))
dbCreateRect(cvid list("CONT" "drawing") list(23.38:54.91 23.60:55.13))
dbCreateRect(cvid list("CONT" "drawing") list(23.85:54.91 24.07:55.13))
dbCreateRect(cvid list("CONT" "drawing") list(24.32:54.91 24.54:55.13))
dbCreateRect(cvid list("CONT" "drawing") list(24.79:54.91 25.01:55.13))
dbCreateRect(cvid list("CONT" "drawing") list(25.26:54.91 25.48:55.13))
dbCreateRect(cvid list("CONT" "drawing") list(25.73:54.91 25.95:55.13))
dbCreateRect(cvid list("CONT" "drawing") list(26.20:54.91 26.42:55.13))
dbCreateRect(cvid list("CONT" "drawing") list(26.67:54.91 26.89:55.13))
dbCreateRect(cvid list("CONT" "drawing") list(27.14:54.91 27.36:55.13))
dbCreateRect(cvid list("CONT" "drawing") list(27.61:54.91 27.83:55.13))
dbCreateRect(cvid list("CONT" "drawing") list(28.08:54.91 28.30:55.13))
dbCreateRect(cvid list("CONT" "drawing") list(28.55:54.91 28.77:55.13))
dbCreateRect(cvid list("CONT" "drawing") list(29.02:54.91 29.24:55.13))
dbCreateRect(cvid list("CONT" "drawing") list(29.49:54.91 29.71:55.13))
dbCreateRect(cvid list("CONT" "drawing") list(29.96:54.91 30.18:55.13))
dbCreateRect(cvid list("CONT" "drawing") list(30.43:54.91 30.65:55.13))
dbCreateRect(cvid list("CONT" "drawing") list(30.90:54.91 31.12:55.13))
dbCreateRect(cvid list("CONT" "drawing") list(31.37:54.91 31.59:55.13))
dbCreateRect(cvid list("CONT" "drawing") list(31.84:54.91 32.06:55.13))
dbCreateRect(cvid list("CONT" "drawing") list(32.31:54.91 32.53:55.13))
dbCreateRect(cvid list("CONT" "drawing") list(32.78:54.91 33.00:55.13))
dbCreateRect(cvid list("CONT" "drawing") list(33.25:54.91 33.47:55.13))
dbCreateRect(cvid list("CONT" "drawing") list(33.72:54.91 33.94:55.13))
dbCreateRect(cvid list("CONT" "drawing") list(34.19:54.91 34.41:55.13))
dbCreateRect(cvid list("CONT" "drawing") list(34.66:54.91 34.88:55.13))
dbCreateRect(cvid list("CONT" "drawing") list(35.13:54.91 35.35:55.13))
dbCreateRect(cvid list("CONT" "drawing") list(35.60:54.91 35.82:55.13))
dbCreateRect(cvid list("CONT" "drawing") list(36.07:54.91 36.29:55.13))
dbCreateRect(cvid list("CONT" "drawing") list(36.54:54.91 36.76:55.13))
dbCreateRect(cvid list("CONT" "drawing") list(37.01:54.91 37.23:55.13))
dbCreateRect(cvid list("CONT" "drawing") list(37.48:54.91 37.70:55.13))
dbCreateRect(cvid list("CONT" "drawing") list(37.95:54.91 38.17:55.13))
dbCreateRect(cvid list("CONT" "drawing") list(38.42:54.91 38.64:55.13))
dbCreateRect(cvid list("CONT" "drawing") list(38.89:54.91 39.11:55.13))
dbCreateRect(cvid list("CONT" "drawing") list(39.36:54.91 39.58:55.13))
dbCreateRect(cvid list("CONT" "drawing") list(39.83:54.91 40.05:55.13))
dbCreateRect(cvid list("CONT" "drawing") list(40.30:54.91 40.52:55.13))
dbCreateRect(cvid list("CONT" "drawing") list(40.77:54.91 40.99:55.13))
dbCreateRect(cvid list("CONT" "drawing") list(41.24:54.91 41.46:55.13))
dbCreateRect(cvid list("CONT" "drawing") list(41.71:54.91 41.93:55.13))
dbCreateRect(cvid list("CONT" "drawing") list(42.18:54.91 42.40:55.13))
dbCreateRect(cvid list("CONT" "drawing") list(42.65:54.91 42.87:55.13))
dbCreateRect(cvid list("CONT" "drawing") list(43.12:54.91 43.34:55.13))
dbCreateRect(cvid list("CONT" "drawing") list(43.59:54.91 43.81:55.13))
dbCreateRect(cvid list("CONT" "drawing") list(44.06:54.91 44.28:55.13))
dbCreateRect(cvid list("CONT" "drawing") list(44.53:54.91 44.75:55.13))
dbCreateRect(cvid list("CONT" "drawing") list(45.00:54.91 45.22:55.13))
dbCreateRect(cvid list("CONT" "drawing") list(45.47:54.91 45.69:55.13))
dbCreateRect(cvid list("CONT" "drawing") list(45.94:54.91 46.16:55.13))
dbCreateRect(cvid list("CONT" "drawing") list(46.41:54.91 46.63:55.13))
dbCreateRect(cvid list("CONT" "drawing") list(46.88:54.91 47.10:55.13))
dbCreateRect(cvid list("CONT" "drawing") list(47.35:54.91 47.57:55.13))
dbCreateRect(cvid list("CONT" "drawing") list(47.82:54.91 48.04:55.13))
dbCreateRect(cvid list("CONT" "drawing") list(48.29:54.91 48.51:55.13))
dbCreateRect(cvid list("CONT" "drawing") list(48.76:54.91 48.98:55.13))
dbCreateRect(cvid list("CONT" "drawing") list(49.23:54.91 49.45:55.13))
dbCreateRect(cvid list("CONT" "drawing") list(49.70:54.91 49.92:55.13))
dbCreateRect(cvid list("CONT" "drawing") list(50.17:54.91 50.39:55.13))
dbCreateRect(cvid list("CONT" "drawing") list(50.64:54.91 50.86:55.13))
dbCreateRect(cvid list("CONT" "drawing") list(51.11:54.91 51.33:55.13))
dbCreateRect(cvid list("CONT" "drawing") list(51.58:54.91 51.80:55.13))
dbCreateRect(cvid list("CONT" "drawing") list(52.05:54.91 52.27:55.13))
dbCreateRect(cvid list("CONT" "drawing") list(52.52:54.91 52.74:55.13))
dbCreateRect(cvid list("CONT" "drawing") list(52.99:54.91 53.21:55.13))
dbCreateRect(cvid list("CONT" "drawing") list(53.46:54.91 53.68:55.13))
dbCreateRect(cvid list("CONT" "drawing") list(53.93:54.91 54.15:55.13))
dbCreateRect(cvid list("CONT" "drawing") list(54.40:54.91 54.62:55.13))
dbCreateRect(cvid list("CONT" "drawing") list(54.87:54.91 55.09:55.13))
dbCreateRect(cvid list("CONT" "drawing") list(55.34:54.91 55.56:55.13))
dbCreateRect(cvid list("CONT" "drawing") list(55.81:54.91 56.03:55.13))
dbCreateRect(cvid list("CONT" "drawing") list(56.28:54.91 56.50:55.13))
dbCreateRect(cvid list("CONT" "drawing") list(56.75:54.91 56.97:55.13))
dbCreateRect(cvid list("CONT" "drawing") list(57.22:54.91 57.44:55.13))
dbCreateRect(cvid list("CONT" "drawing") list(57.69:54.91 57.91:55.13))
dbCreateRect(cvid list("CONT" "drawing") list(58.16:54.91 58.38:55.13))
dbCreateRect(cvid list("CONT" "drawing") list(58.63:54.91 58.85:55.13))
dbCreateRect(cvid list("CONT" "drawing") list(59.10:54.91 59.32:55.13))
dbCreateRect(cvid list("CONT" "drawing") list(59.57:54.91 59.79:55.13))
dbCreateRect(cvid list("CONT" "drawing") list(60.04:54.91 60.26:55.13))
dbCreateRect(cvid list("CONT" "drawing") list(60.51:54.91 60.73:55.13))
dbCreateRect(cvid list("CONT" "drawing") list(60.98:54.91 61.20:55.13))
dbCreateRect(cvid list("CONT" "drawing") list(61.45:54.91 61.67:55.13))
dbCreateRect(cvid list("CONT" "drawing") list(61.92:54.91 62.14:55.13))
dbCreateRect(cvid list("CONT" "drawing") list(62.39:54.91 62.61:55.13))
dbCreateRect(cvid list("CONT" "drawing") list(62.86:54.91 63.08:55.13))
dbCreateRect(cvid list("CONT" "drawing") list(63.33:54.91 63.55:55.13))
dbCreateRect(cvid list("CONT" "drawing") list(63.80:54.91 64.02:55.13))
dbCreateRect(cvid list("CONT" "drawing") list(64.27:54.91 64.49:55.13))
dbCreateRect(cvid list("CONT" "drawing") list(64.74:54.91 64.96:55.13))
dbCreateRect(cvid list("CONT" "drawing") list(65.21:54.91 65.43:55.13))
dbCreateRect(cvid list("CONT" "drawing") list(65.68:54.91 65.90:55.13))
dbCreateRect(cvid list("CONT" "drawing") list(66.15:54.91 66.37:55.13))
dbCreateRect(cvid list("CONT" "drawing") list(66.62:54.91 66.84:55.13))
dbCreateRect(cvid list("CONT" "drawing") list(67.09:54.91 67.31:55.13))
dbCreateRect(cvid list("CONT" "drawing") list(67.56:54.91 67.78:55.13))
dbCreateRect(cvid list("CONT" "drawing") list(68.03:54.91 68.25:55.13))
dbCreateRect(cvid list("CONT" "drawing") list(68.50:54.91 68.72:55.13))
dbCreateRect(cvid list("CONT" "drawing") list(68.97:54.91 69.19:55.13))
dbCreateRect(cvid list("CONT" "drawing") list(69.44:54.91 69.66:55.13))
dbCreateRect(cvid list("CONT" "drawing") list(69.91:54.91 70.13:55.13))
dbCreateRect(cvid list("CONT" "drawing") list(70.38:54.91 70.60:55.13))
dbCreateRect(cvid list("CONT" "drawing") list(70.85:54.91 71.07:55.13))
dbCreateRect(cvid list("CONT" "drawing") list(71.32:54.91 71.54:55.13))
dbCreateRect(cvid list("CONT" "drawing") list(71.79:54.91 72.01:55.13))
dbCreateRect(cvid list("CONT" "drawing") list(72.26:54.91 72.48:55.13))
dbCreateRect(cvid list("CONT" "drawing") list(72.73:54.91 72.95:55.13))
dbCreateRect(cvid list("CONT" "drawing") list(73.20:54.91 73.42:55.13))
dbCreateRect(cvid list("CONT" "drawing") list(73.67:54.91 73.89:55.13))
dbCreateRect(cvid list("CONT" "drawing") list(74.14:54.91 74.36:55.13))
dbCreateRect(cvid list("CONT" "drawing") list(74.61:54.91 74.83:55.13))
dbCreateRect(cvid list("CONT" "drawing") list(75.08:54.91 75.30:55.13))
dbCreateRect(cvid list("CONT" "drawing") list(75.55:54.91 75.77:55.13))
dbCreateRect(cvid list("CONT" "drawing") list(76.02:54.91 76.24:55.13))
dbCreateRect(cvid list("CONT" "drawing") list(76.49:54.91 76.71:55.13))
dbCreateRect(cvid list("CONT" "drawing") list(76.96:54.91 77.18:55.13))
dbCreateRect(cvid list("CONT" "drawing") list(77.43:54.91 77.65:55.13))
dbCreateRect(cvid list("CONT" "drawing") list(77.90:54.91 78.12:55.13))
dbCreateRect(cvid list("CONT" "drawing") list(78.37:54.91 78.59:55.13))
dbCreateRect(cvid list("CONT" "drawing") list(78.84:54.91 79.06:55.13))
dbCreateRect(cvid list("NIMP" "drawing") list(1.21:54.61 79.61:55.43))
dbCreateRect(cvid list("NWELL" "drawing") list(0.96:54.36 79.86:55.68))
dbCreateRect(cvid list("DIFF" "drawing") list(79.43:55.25 79.89:77.88))
dbCreateRect(cvid list("METAL1" "drawing") list(79.43:55.25 79.89:77.88))
dbCreateRect(cvid list("CONT" "drawing") list(79.55:55.64 79.77:55.86))
dbCreateRect(cvid list("CONT" "drawing") list(79.55:56.11 79.77:56.33))
dbCreateRect(cvid list("CONT" "drawing") list(79.55:56.59 79.77:56.80))
dbCreateRect(cvid list("CONT" "drawing") list(79.55:57.05 79.77:57.27))
dbCreateRect(cvid list("CONT" "drawing") list(79.55:57.52 79.77:57.74))
dbCreateRect(cvid list("CONT" "drawing") list(79.55:57.99 79.77:58.21))
dbCreateRect(cvid list("CONT" "drawing") list(79.55:58.46 79.77:58.68))
dbCreateRect(cvid list("CONT" "drawing") list(79.55:58.94 79.77:59.16))
dbCreateRect(cvid list("CONT" "drawing") list(79.55:59.41 79.77:59.62))
dbCreateRect(cvid list("CONT" "drawing") list(79.55:59.88 79.77:60.09))
dbCreateRect(cvid list("CONT" "drawing") list(79.55:60.34 79.77:60.56))
dbCreateRect(cvid list("CONT" "drawing") list(79.55:60.81 79.77:61.03))
dbCreateRect(cvid list("CONT" "drawing") list(79.55:61.28 79.77:61.50))
dbCreateRect(cvid list("CONT" "drawing") list(79.55:61.75 79.77:61.97))
dbCreateRect(cvid list("CONT" "drawing") list(79.55:62.23 79.77:62.45))
dbCreateRect(cvid list("CONT" "drawing") list(79.55:62.70 79.77:62.91))
dbCreateRect(cvid list("CONT" "drawing") list(79.55:63.16 79.77:63.38))
dbCreateRect(cvid list("CONT" "drawing") list(79.55:63.63 79.77:63.85))
dbCreateRect(cvid list("CONT" "drawing") list(79.55:64.11 79.77:64.33))
dbCreateRect(cvid list("CONT" "drawing") list(79.55:64.58 79.77:64.80))
dbCreateRect(cvid list("CONT" "drawing") list(79.55:65.05 79.77:65.27))
dbCreateRect(cvid list("CONT" "drawing") list(79.55:65.52 79.77:65.73))
dbCreateRect(cvid list("CONT" "drawing") list(79.55:65.98 79.77:66.20))
dbCreateRect(cvid list("CONT" "drawing") list(79.55:66.45 79.77:66.67))
dbCreateRect(cvid list("CONT" "drawing") list(79.55:66.92 79.77:67.14))
dbCreateRect(cvid list("CONT" "drawing") list(79.55:67.39 79.77:67.61))
dbCreateRect(cvid list("CONT" "drawing") list(79.55:67.86 79.77:68.08))
dbCreateRect(cvid list("CONT" "drawing") list(79.55:68.33 79.77:68.55))
dbCreateRect(cvid list("CONT" "drawing") list(79.55:68.80 79.77:69.02))
dbCreateRect(cvid list("CONT" "drawing") list(79.55:69.27 79.77:69.49))
dbCreateRect(cvid list("CONT" "drawing") list(79.55:69.75 79.77:69.97))
dbCreateRect(cvid list("CONT" "drawing") list(79.55:70.22 79.77:70.44))
dbCreateRect(cvid list("CONT" "drawing") list(79.55:70.69 79.77:70.91))
dbCreateRect(cvid list("CONT" "drawing") list(79.55:71.16 79.77:71.38))
dbCreateRect(cvid list("CONT" "drawing") list(79.55:71.62 79.77:71.84))
dbCreateRect(cvid list("CONT" "drawing") list(79.55:72.09 79.77:72.31))
dbCreateRect(cvid list("CONT" "drawing") list(79.55:72.56 79.77:72.78))
dbCreateRect(cvid list("CONT" "drawing") list(79.55:73.03 79.77:73.25))
dbCreateRect(cvid list("CONT" "drawing") list(79.55:73.50 79.77:73.72))
dbCreateRect(cvid list("CONT" "drawing") list(79.55:73.97 79.77:74.19))
dbCreateRect(cvid list("CONT" "drawing") list(79.55:74.44 79.77:74.66))
dbCreateRect(cvid list("CONT" "drawing") list(79.55:74.91 79.77:75.13))
dbCreateRect(cvid list("CONT" "drawing") list(79.55:75.38 79.77:75.60))
dbCreateRect(cvid list("CONT" "drawing") list(79.55:75.85 79.77:76.07))
dbCreateRect(cvid list("CONT" "drawing") list(79.55:76.33 79.77:76.55))
dbCreateRect(cvid list("CONT" "drawing") list(79.55:76.80 79.77:77.02))
dbCreateRect(cvid list("CONT" "drawing") list(79.55:77.27 79.77:77.48))
dbCreateRect(cvid list("NIMP" "drawing") list(79.25:55.07 80.07:78.06))
dbCreateRect(cvid list("NWELL" "drawing") list(79.00:54.82 80.32:78.31))
dbCreateRect(cvid list("DIFF" "drawing") list(1.39:77.88 79.43:78.34))
dbCreateRect(cvid list("METAL1" "drawing") list(1.39:77.88 79.43:78.34))
dbCreateRect(cvid list("CONT" "drawing") list(1.76:78.00 1.98:78.22))
dbCreateRect(cvid list("CONT" "drawing") list(2.23:78.00 2.45:78.22))
dbCreateRect(cvid list("CONT" "drawing") list(2.70:78.00 2.92:78.22))
dbCreateRect(cvid list("CONT" "drawing") list(3.17:78.00 3.39:78.22))
dbCreateRect(cvid list("CONT" "drawing") list(3.64:78.00 3.86:78.22))
dbCreateRect(cvid list("CONT" "drawing") list(4.11:78.00 4.33:78.22))
dbCreateRect(cvid list("CONT" "drawing") list(4.58:78.00 4.80:78.22))
dbCreateRect(cvid list("CONT" "drawing") list(5.05:78.00 5.27:78.22))
dbCreateRect(cvid list("CONT" "drawing") list(5.52:78.00 5.74:78.22))
dbCreateRect(cvid list("CONT" "drawing") list(5.99:78.00 6.21:78.22))
dbCreateRect(cvid list("CONT" "drawing") list(6.46:78.00 6.68:78.22))
dbCreateRect(cvid list("CONT" "drawing") list(6.93:78.00 7.15:78.22))
dbCreateRect(cvid list("CONT" "drawing") list(7.40:78.00 7.62:78.22))
dbCreateRect(cvid list("CONT" "drawing") list(7.87:78.00 8.09:78.22))
dbCreateRect(cvid list("CONT" "drawing") list(8.34:78.00 8.56:78.22))
dbCreateRect(cvid list("CONT" "drawing") list(8.81:78.00 9.03:78.22))
dbCreateRect(cvid list("CONT" "drawing") list(9.28:78.00 9.50:78.22))
dbCreateRect(cvid list("CONT" "drawing") list(9.75:78.00 9.97:78.22))
dbCreateRect(cvid list("CONT" "drawing") list(10.22:78.00 10.44:78.22))
dbCreateRect(cvid list("CONT" "drawing") list(10.69:78.00 10.91:78.22))
dbCreateRect(cvid list("CONT" "drawing") list(11.16:78.00 11.38:78.22))
dbCreateRect(cvid list("CONT" "drawing") list(11.63:78.00 11.85:78.22))
dbCreateRect(cvid list("CONT" "drawing") list(12.10:78.00 12.32:78.22))
dbCreateRect(cvid list("CONT" "drawing") list(12.57:78.00 12.79:78.22))
dbCreateRect(cvid list("CONT" "drawing") list(13.04:78.00 13.26:78.22))
dbCreateRect(cvid list("CONT" "drawing") list(13.51:78.00 13.73:78.22))
dbCreateRect(cvid list("CONT" "drawing") list(13.98:78.00 14.20:78.22))
dbCreateRect(cvid list("CONT" "drawing") list(14.45:78.00 14.67:78.22))
dbCreateRect(cvid list("CONT" "drawing") list(14.92:78.00 15.14:78.22))
dbCreateRect(cvid list("CONT" "drawing") list(15.39:78.00 15.61:78.22))
dbCreateRect(cvid list("CONT" "drawing") list(15.86:78.00 16.08:78.22))
dbCreateRect(cvid list("CONT" "drawing") list(16.33:78.00 16.55:78.22))
dbCreateRect(cvid list("CONT" "drawing") list(16.80:78.00 17.02:78.22))
dbCreateRect(cvid list("CONT" "drawing") list(17.27:78.00 17.49:78.22))
dbCreateRect(cvid list("CONT" "drawing") list(17.74:78.00 17.96:78.22))
dbCreateRect(cvid list("CONT" "drawing") list(18.21:78.00 18.43:78.22))
dbCreateRect(cvid list("CONT" "drawing") list(18.68:78.00 18.90:78.22))
dbCreateRect(cvid list("CONT" "drawing") list(19.15:78.00 19.37:78.22))
dbCreateRect(cvid list("CONT" "drawing") list(19.62:78.00 19.84:78.22))
dbCreateRect(cvid list("CONT" "drawing") list(20.09:78.00 20.31:78.22))
dbCreateRect(cvid list("CONT" "drawing") list(20.56:78.00 20.78:78.22))
dbCreateRect(cvid list("CONT" "drawing") list(21.03:78.00 21.25:78.22))
dbCreateRect(cvid list("CONT" "drawing") list(21.50:78.00 21.72:78.22))
dbCreateRect(cvid list("CONT" "drawing") list(21.97:78.00 22.19:78.22))
dbCreateRect(cvid list("CONT" "drawing") list(22.44:78.00 22.66:78.22))
dbCreateRect(cvid list("CONT" "drawing") list(22.91:78.00 23.13:78.22))
dbCreateRect(cvid list("CONT" "drawing") list(23.38:78.00 23.60:78.22))
dbCreateRect(cvid list("CONT" "drawing") list(23.85:78.00 24.07:78.22))
dbCreateRect(cvid list("CONT" "drawing") list(24.32:78.00 24.54:78.22))
dbCreateRect(cvid list("CONT" "drawing") list(24.79:78.00 25.01:78.22))
dbCreateRect(cvid list("CONT" "drawing") list(25.26:78.00 25.48:78.22))
dbCreateRect(cvid list("CONT" "drawing") list(25.73:78.00 25.95:78.22))
dbCreateRect(cvid list("CONT" "drawing") list(26.20:78.00 26.42:78.22))
dbCreateRect(cvid list("CONT" "drawing") list(26.67:78.00 26.89:78.22))
dbCreateRect(cvid list("CONT" "drawing") list(27.14:78.00 27.36:78.22))
dbCreateRect(cvid list("CONT" "drawing") list(27.61:78.00 27.83:78.22))
dbCreateRect(cvid list("CONT" "drawing") list(28.08:78.00 28.30:78.22))
dbCreateRect(cvid list("CONT" "drawing") list(28.55:78.00 28.77:78.22))
dbCreateRect(cvid list("CONT" "drawing") list(29.02:78.00 29.24:78.22))
dbCreateRect(cvid list("CONT" "drawing") list(29.49:78.00 29.71:78.22))
dbCreateRect(cvid list("CONT" "drawing") list(29.96:78.00 30.18:78.22))
dbCreateRect(cvid list("CONT" "drawing") list(30.43:78.00 30.65:78.22))
dbCreateRect(cvid list("CONT" "drawing") list(30.90:78.00 31.12:78.22))
dbCreateRect(cvid list("CONT" "drawing") list(31.37:78.00 31.59:78.22))
dbCreateRect(cvid list("CONT" "drawing") list(31.84:78.00 32.06:78.22))
dbCreateRect(cvid list("CONT" "drawing") list(32.31:78.00 32.53:78.22))
dbCreateRect(cvid list("CONT" "drawing") list(32.78:78.00 33.00:78.22))
dbCreateRect(cvid list("CONT" "drawing") list(33.25:78.00 33.47:78.22))
dbCreateRect(cvid list("CONT" "drawing") list(33.72:78.00 33.94:78.22))
dbCreateRect(cvid list("CONT" "drawing") list(34.19:78.00 34.41:78.22))
dbCreateRect(cvid list("CONT" "drawing") list(34.66:78.00 34.88:78.22))
dbCreateRect(cvid list("CONT" "drawing") list(35.13:78.00 35.35:78.22))
dbCreateRect(cvid list("CONT" "drawing") list(35.60:78.00 35.82:78.22))
dbCreateRect(cvid list("CONT" "drawing") list(36.07:78.00 36.29:78.22))
dbCreateRect(cvid list("CONT" "drawing") list(36.54:78.00 36.76:78.22))
dbCreateRect(cvid list("CONT" "drawing") list(37.01:78.00 37.23:78.22))
dbCreateRect(cvid list("CONT" "drawing") list(37.48:78.00 37.70:78.22))
dbCreateRect(cvid list("CONT" "drawing") list(37.95:78.00 38.17:78.22))
dbCreateRect(cvid list("CONT" "drawing") list(38.42:78.00 38.64:78.22))
dbCreateRect(cvid list("CONT" "drawing") list(38.89:78.00 39.11:78.22))
dbCreateRect(cvid list("CONT" "drawing") list(39.36:78.00 39.58:78.22))
dbCreateRect(cvid list("CONT" "drawing") list(39.83:78.00 40.05:78.22))
dbCreateRect(cvid list("CONT" "drawing") list(40.30:78.00 40.52:78.22))
dbCreateRect(cvid list("CONT" "drawing") list(40.77:78.00 40.99:78.22))
dbCreateRect(cvid list("CONT" "drawing") list(41.24:78.00 41.46:78.22))
dbCreateRect(cvid list("CONT" "drawing") list(41.71:78.00 41.93:78.22))
dbCreateRect(cvid list("CONT" "drawing") list(42.18:78.00 42.40:78.22))
dbCreateRect(cvid list("CONT" "drawing") list(42.65:78.00 42.87:78.22))
dbCreateRect(cvid list("CONT" "drawing") list(43.12:78.00 43.34:78.22))
dbCreateRect(cvid list("CONT" "drawing") list(43.59:78.00 43.81:78.22))
dbCreateRect(cvid list("CONT" "drawing") list(44.06:78.00 44.28:78.22))
dbCreateRect(cvid list("CONT" "drawing") list(44.53:78.00 44.75:78.22))
dbCreateRect(cvid list("CONT" "drawing") list(45.00:78.00 45.22:78.22))
dbCreateRect(cvid list("CONT" "drawing") list(45.47:78.00 45.69:78.22))
dbCreateRect(cvid list("CONT" "drawing") list(45.94:78.00 46.16:78.22))
dbCreateRect(cvid list("CONT" "drawing") list(46.41:78.00 46.63:78.22))
dbCreateRect(cvid list("CONT" "drawing") list(46.88:78.00 47.10:78.22))
dbCreateRect(cvid list("CONT" "drawing") list(47.35:78.00 47.57:78.22))
dbCreateRect(cvid list("CONT" "drawing") list(47.82:78.00 48.04:78.22))
dbCreateRect(cvid list("CONT" "drawing") list(48.29:78.00 48.51:78.22))
dbCreateRect(cvid list("CONT" "drawing") list(48.76:78.00 48.98:78.22))
dbCreateRect(cvid list("CONT" "drawing") list(49.23:78.00 49.45:78.22))
dbCreateRect(cvid list("CONT" "drawing") list(49.70:78.00 49.92:78.22))
dbCreateRect(cvid list("CONT" "drawing") list(50.17:78.00 50.39:78.22))
dbCreateRect(cvid list("CONT" "drawing") list(50.64:78.00 50.86:78.22))
dbCreateRect(cvid list("CONT" "drawing") list(51.11:78.00 51.33:78.22))
dbCreateRect(cvid list("CONT" "drawing") list(51.58:78.00 51.80:78.22))
dbCreateRect(cvid list("CONT" "drawing") list(52.05:78.00 52.27:78.22))
dbCreateRect(cvid list("CONT" "drawing") list(52.52:78.00 52.74:78.22))
dbCreateRect(cvid list("CONT" "drawing") list(52.99:78.00 53.21:78.22))
dbCreateRect(cvid list("CONT" "drawing") list(53.46:78.00 53.68:78.22))
dbCreateRect(cvid list("CONT" "drawing") list(53.93:78.00 54.15:78.22))
dbCreateRect(cvid list("CONT" "drawing") list(54.40:78.00 54.62:78.22))
dbCreateRect(cvid list("CONT" "drawing") list(54.87:78.00 55.09:78.22))
dbCreateRect(cvid list("CONT" "drawing") list(55.34:78.00 55.56:78.22))
dbCreateRect(cvid list("CONT" "drawing") list(55.81:78.00 56.03:78.22))
dbCreateRect(cvid list("CONT" "drawing") list(56.28:78.00 56.50:78.22))
dbCreateRect(cvid list("CONT" "drawing") list(56.75:78.00 56.97:78.22))
dbCreateRect(cvid list("CONT" "drawing") list(57.22:78.00 57.44:78.22))
dbCreateRect(cvid list("CONT" "drawing") list(57.69:78.00 57.91:78.22))
dbCreateRect(cvid list("CONT" "drawing") list(58.16:78.00 58.38:78.22))
dbCreateRect(cvid list("CONT" "drawing") list(58.63:78.00 58.85:78.22))
dbCreateRect(cvid list("CONT" "drawing") list(59.10:78.00 59.32:78.22))
dbCreateRect(cvid list("CONT" "drawing") list(59.57:78.00 59.79:78.22))
dbCreateRect(cvid list("CONT" "drawing") list(60.04:78.00 60.26:78.22))
dbCreateRect(cvid list("CONT" "drawing") list(60.51:78.00 60.73:78.22))
dbCreateRect(cvid list("CONT" "drawing") list(60.98:78.00 61.20:78.22))
dbCreateRect(cvid list("CONT" "drawing") list(61.45:78.00 61.67:78.22))
dbCreateRect(cvid list("CONT" "drawing") list(61.92:78.00 62.14:78.22))
dbCreateRect(cvid list("CONT" "drawing") list(62.39:78.00 62.61:78.22))
dbCreateRect(cvid list("CONT" "drawing") list(62.86:78.00 63.08:78.22))
dbCreateRect(cvid list("CONT" "drawing") list(63.33:78.00 63.55:78.22))
dbCreateRect(cvid list("CONT" "drawing") list(63.80:78.00 64.02:78.22))
dbCreateRect(cvid list("CONT" "drawing") list(64.27:78.00 64.49:78.22))
dbCreateRect(cvid list("CONT" "drawing") list(64.74:78.00 64.96:78.22))
dbCreateRect(cvid list("CONT" "drawing") list(65.21:78.00 65.43:78.22))
dbCreateRect(cvid list("CONT" "drawing") list(65.68:78.00 65.90:78.22))
dbCreateRect(cvid list("CONT" "drawing") list(66.15:78.00 66.37:78.22))
dbCreateRect(cvid list("CONT" "drawing") list(66.62:78.00 66.84:78.22))
dbCreateRect(cvid list("CONT" "drawing") list(67.09:78.00 67.31:78.22))
dbCreateRect(cvid list("CONT" "drawing") list(67.56:78.00 67.78:78.22))
dbCreateRect(cvid list("CONT" "drawing") list(68.03:78.00 68.25:78.22))
dbCreateRect(cvid list("CONT" "drawing") list(68.50:78.00 68.72:78.22))
dbCreateRect(cvid list("CONT" "drawing") list(68.97:78.00 69.19:78.22))
dbCreateRect(cvid list("CONT" "drawing") list(69.44:78.00 69.66:78.22))
dbCreateRect(cvid list("CONT" "drawing") list(69.91:78.00 70.13:78.22))
dbCreateRect(cvid list("CONT" "drawing") list(70.38:78.00 70.60:78.22))
dbCreateRect(cvid list("CONT" "drawing") list(70.85:78.00 71.07:78.22))
dbCreateRect(cvid list("CONT" "drawing") list(71.32:78.00 71.54:78.22))
dbCreateRect(cvid list("CONT" "drawing") list(71.79:78.00 72.01:78.22))
dbCreateRect(cvid list("CONT" "drawing") list(72.26:78.00 72.48:78.22))
dbCreateRect(cvid list("CONT" "drawing") list(72.73:78.00 72.95:78.22))
dbCreateRect(cvid list("CONT" "drawing") list(73.20:78.00 73.42:78.22))
dbCreateRect(cvid list("CONT" "drawing") list(73.67:78.00 73.89:78.22))
dbCreateRect(cvid list("CONT" "drawing") list(74.14:78.00 74.36:78.22))
dbCreateRect(cvid list("CONT" "drawing") list(74.61:78.00 74.83:78.22))
dbCreateRect(cvid list("CONT" "drawing") list(75.08:78.00 75.30:78.22))
dbCreateRect(cvid list("CONT" "drawing") list(75.55:78.00 75.77:78.22))
dbCreateRect(cvid list("CONT" "drawing") list(76.02:78.00 76.24:78.22))
dbCreateRect(cvid list("CONT" "drawing") list(76.49:78.00 76.71:78.22))
dbCreateRect(cvid list("CONT" "drawing") list(76.96:78.00 77.18:78.22))
dbCreateRect(cvid list("CONT" "drawing") list(77.43:78.00 77.65:78.22))
dbCreateRect(cvid list("CONT" "drawing") list(77.90:78.00 78.12:78.22))
dbCreateRect(cvid list("CONT" "drawing") list(78.37:78.00 78.59:78.22))
dbCreateRect(cvid list("CONT" "drawing") list(78.84:78.00 79.06:78.22))
dbCreateRect(cvid list("NIMP" "drawing") list(1.21:77.70 79.61:78.52))
dbCreateRect(cvid list("NWELL" "drawing") list(0.96:77.45 79.86:78.77))
dbCreateParamInst(cvid masterpmos "I62" list(2.580 29.360) "R0" 1 list(list("w" "string" "21.00u") list("l" "string" "2.00u") ))
dbCreateParamInst(cvid masterpmos "M18.1" list(7.120 29.360) "MY" 1 list(list("w" "string" "21.00u") list("l" "string" "2.00u") ))
dbCreateParamInst(cvid masterpmos "M4.3" list(7.660 29.360) "R0" 1 list(list("w" "string" "21.00u") list("l" "string" "2.00u") ))
dbCreateParamInst(cvid masterpmos "M4.4" list(12.200 29.360) "MY" 1 list(list("w" "string" "21.00u") list("l" "string" "2.00u") ))
dbCreateParamInst(cvid masterpmos "M18.2" list(12.740 29.360) "R0" 1 list(list("w" "string" "21.00u") list("l" "string" "2.00u") ))
dbCreateParamInst(cvid masterpmos "I38" list(17.280 29.360) "MY" 1 list(list("w" "string" "21.00u") list("l" "string" "2.00u") ))
dbCreateRect(cvid list("METAL1" "drawing") list(2.11:29.36 2.51:50.36))
dbCreateRect(cvid list("METAL1" "drawing") list(4.65:29.36 5.05:50.36))
dbCreateRect(cvid list("METAL1" "drawing") list(7.19:29.36 7.59:50.36))
dbCreateRect(cvid list("METAL1" "drawing") list(9.73:29.36 10.13:50.36))
dbCreateRect(cvid list("METAL1" "drawing") list(12.27:29.36 12.67:50.36))
dbCreateRect(cvid list("METAL1" "drawing") list(14.81:29.36 15.21:50.36))
dbCreateRect(cvid list("METAL1" "drawing") list(17.35:29.36 17.75:50.36))
dbCreateRect(cvid list("POLY1" "drawing") list(2.58:28.72 4.58:29.14))
dbCreateRect(cvid list("METAL1" "drawing") list(2.70:28.72 4.45:29.14))
dbCreateRect(cvid list("CONT" "drawing") list(3.00:28.82 3.22:29.04))
dbCreateRect(cvid list("CONT" "drawing") list(3.47:28.82 3.69:29.04))
dbCreateRect(cvid list("CONT" "drawing") list(3.94:28.82 4.16:29.04))
dbCreateRect(cvid list("POLY1" "drawing") list(5.12:28.72 7.12:29.14))
dbCreateRect(cvid list("METAL1" "drawing") list(5.24:28.72 6.99:29.14))
dbCreateRect(cvid list("CONT" "drawing") list(5.54:28.82 5.76:29.04))
dbCreateRect(cvid list("CONT" "drawing") list(6.01:28.82 6.23:29.04))
dbCreateRect(cvid list("CONT" "drawing") list(6.48:28.82 6.70:29.04))
dbCreateRect(cvid list("POLY1" "drawing") list(7.66:28.72 9.66:29.14))
dbCreateRect(cvid list("METAL1" "drawing") list(7.78:28.72 9.54:29.14))
dbCreateRect(cvid list("CONT" "drawing") list(8.08:28.82 8.30:29.04))
dbCreateRect(cvid list("CONT" "drawing") list(8.55:28.82 8.77:29.04))
dbCreateRect(cvid list("CONT" "drawing") list(9.02:28.82 9.24:29.04))
dbCreateRect(cvid list("POLY1" "drawing") list(10.20:28.72 12.20:29.14))
dbCreateRect(cvid list("METAL1" "drawing") list(10.32:28.72 12.07:29.14))
dbCreateRect(cvid list("CONT" "drawing") list(10.62:28.82 10.84:29.04))
dbCreateRect(cvid list("CONT" "drawing") list(11.09:28.82 11.31:29.04))
dbCreateRect(cvid list("CONT" "drawing") list(11.56:28.82 11.78:29.04))
dbCreateRect(cvid list("POLY1" "drawing") list(12.74:28.72 14.74:29.14))
dbCreateRect(cvid list("METAL1" "drawing") list(12.86:28.72 14.61:29.14))
dbCreateRect(cvid list("CONT" "drawing") list(13.16:28.82 13.38:29.04))
dbCreateRect(cvid list("CONT" "drawing") list(13.63:28.82 13.85:29.04))
dbCreateRect(cvid list("CONT" "drawing") list(14.10:28.82 14.32:29.04))
dbCreateRect(cvid list("POLY1" "drawing") list(15.28:28.72 17.28:29.14))
dbCreateRect(cvid list("METAL1" "drawing") list(15.41:28.72 17.16:29.14))
dbCreateRect(cvid list("CONT" "drawing") list(15.70:28.82 15.92:29.04))
dbCreateRect(cvid list("CONT" "drawing") list(16.17:28.82 16.39:29.04))
dbCreateRect(cvid list("CONT" "drawing") list(16.64:28.82 16.86:29.04))
dbCreateParamInst(cvid masterpmos "I64" list(2.580 6.220) "R0" 1 list(list("w" "string" "21.00u") list("l" "string" "2.00u") ))
dbCreateParamInst(cvid masterpmos "M4.1" list(7.120 6.220) "MY" 1 list(list("w" "string" "21.00u") list("l" "string" "2.00u") ))
dbCreateParamInst(cvid masterpmos "M18.4" list(7.660 6.220) "R0" 1 list(list("w" "string" "21.00u") list("l" "string" "2.00u") ))
dbCreateParamInst(cvid masterpmos "M18.3" list(12.200 6.220) "MY" 1 list(list("w" "string" "21.00u") list("l" "string" "2.00u") ))
dbCreateParamInst(cvid masterpmos "M4.2" list(12.740 6.220) "R0" 1 list(list("w" "string" "21.00u") list("l" "string" "2.00u") ))
dbCreateParamInst(cvid masterpmos "I65" list(17.280 6.220) "MY" 1 list(list("w" "string" "21.00u") list("l" "string" "2.00u") ))
dbCreateRect(cvid list("METAL1" "drawing") list(2.11:6.22 2.51:27.22))
dbCreateRect(cvid list("METAL1" "drawing") list(4.65:6.22 5.05:27.22))
dbCreateRect(cvid list("METAL1" "drawing") list(7.19:6.22 7.59:27.22))
dbCreateRect(cvid list("METAL1" "drawing") list(9.73:6.22 10.13:27.22))
dbCreateRect(cvid list("METAL1" "drawing") list(12.27:6.22 12.67:27.22))
dbCreateRect(cvid list("METAL1" "drawing") list(14.81:6.22 15.21:27.22))
dbCreateRect(cvid list("METAL1" "drawing") list(17.35:6.22 17.75:27.22))
dbCreateRect(cvid list("POLY1" "drawing") list(2.58:27.44 4.58:27.86))
dbCreateRect(cvid list("METAL1" "drawing") list(2.70:27.44 4.45:27.86))
dbCreateRect(cvid list("CONT" "drawing") list(3.00:27.54 3.22:27.76))
dbCreateRect(cvid list("CONT" "drawing") list(3.47:27.54 3.69:27.76))
dbCreateRect(cvid list("CONT" "drawing") list(3.94:27.54 4.16:27.76))
dbCreateRect(cvid list("POLY1" "drawing") list(5.12:27.44 7.12:27.86))
dbCreateRect(cvid list("METAL1" "drawing") list(5.24:27.44 6.99:27.86))
dbCreateRect(cvid list("CONT" "drawing") list(5.54:27.54 5.76:27.76))
dbCreateRect(cvid list("CONT" "drawing") list(6.01:27.54 6.23:27.76))
dbCreateRect(cvid list("CONT" "drawing") list(6.48:27.54 6.70:27.76))
dbCreateRect(cvid list("POLY1" "drawing") list(7.66:27.44 9.66:27.86))
dbCreateRect(cvid list("METAL1" "drawing") list(7.78:27.44 9.54:27.86))
dbCreateRect(cvid list("CONT" "drawing") list(8.08:27.54 8.30:27.76))
dbCreateRect(cvid list("CONT" "drawing") list(8.55:27.54 8.77:27.76))
dbCreateRect(cvid list("CONT" "drawing") list(9.02:27.54 9.24:27.76))
dbCreateRect(cvid list("POLY1" "drawing") list(10.20:27.44 12.20:27.86))
dbCreateRect(cvid list("METAL1" "drawing") list(10.32:27.44 12.07:27.86))
dbCreateRect(cvid list("CONT" "drawing") list(10.62:27.54 10.84:27.76))
dbCreateRect(cvid list("CONT" "drawing") list(11.09:27.54 11.31:27.76))
dbCreateRect(cvid list("CONT" "drawing") list(11.56:27.54 11.78:27.76))
dbCreateRect(cvid list("POLY1" "drawing") list(12.74:27.44 14.74:27.86))
dbCreateRect(cvid list("METAL1" "drawing") list(12.86:27.44 14.61:27.86))
dbCreateRect(cvid list("CONT" "drawing") list(13.16:27.54 13.38:27.76))
dbCreateRect(cvid list("CONT" "drawing") list(13.63:27.54 13.85:27.76))
dbCreateRect(cvid list("CONT" "drawing") list(14.10:27.54 14.32:27.76))
dbCreateRect(cvid list("POLY1" "drawing") list(15.28:27.44 17.28:27.86))
dbCreateRect(cvid list("METAL1" "drawing") list(15.41:27.44 17.16:27.86))
dbCreateRect(cvid list("CONT" "drawing") list(15.70:27.54 15.92:27.76))
dbCreateRect(cvid list("CONT" "drawing") list(16.17:27.54 16.39:27.76))
dbCreateRect(cvid list("CONT" "drawing") list(16.64:27.54 16.86:27.76))
dbCreateRect(cvid list("DIFF" "drawing") list(0.93:5.05 1.39:5.51))
dbCreateRect(cvid list("METAL1" "drawing") list(0.93:5.05 1.39:5.51))
dbCreateRect(cvid list("CONT" "drawing") list(1.05:5.17 1.27:5.39))
dbCreateRect(cvid list("NIMP" "drawing") list(0.75:4.87 1.57:5.69))
dbCreateRect(cvid list("NWELL" "drawing") list(0.50:4.62 1.82:5.94))
dbCreateRect(cvid list("DIFF" "drawing") list(18.47:5.05 18.93:5.51))
dbCreateRect(cvid list("METAL1" "drawing") list(18.47:5.05 18.93:5.51))
dbCreateRect(cvid list("CONT" "drawing") list(18.59:5.17 18.81:5.39))
dbCreateRect(cvid list("NIMP" "drawing") list(18.29:4.87 19.11:5.69))
dbCreateRect(cvid list("NWELL" "drawing") list(18.04:4.62 19.36:5.94))
dbCreateRect(cvid list("DIFF" "drawing") list(0.93:51.07 1.39:51.53))
dbCreateRect(cvid list("METAL1" "drawing") list(0.93:51.07 1.39:51.53))
dbCreateRect(cvid list("CONT" "drawing") list(1.05:51.19 1.27:51.41))
dbCreateRect(cvid list("NIMP" "drawing") list(0.75:50.89 1.57:51.71))
dbCreateRect(cvid list("NWELL" "drawing") list(0.50:50.64 1.82:51.96))
dbCreateRect(cvid list("DIFF" "drawing") list(18.47:51.07 18.93:51.53))
dbCreateRect(cvid list("METAL1" "drawing") list(18.47:51.07 18.93:51.53))
dbCreateRect(cvid list("CONT" "drawing") list(18.59:51.19 18.81:51.41))
dbCreateRect(cvid list("NIMP" "drawing") list(18.29:50.89 19.11:51.71))
dbCreateRect(cvid list("NWELL" "drawing") list(18.04:50.64 19.36:51.96))
dbCreateRect(cvid list("DIFF" "drawing") list(0.93:5.51 1.39:51.07))
dbCreateRect(cvid list("METAL1" "drawing") list(0.93:5.51 1.39:51.07))
dbCreateRect(cvid list("CONT" "drawing") list(1.05:5.62 1.27:5.84))
dbCreateRect(cvid list("CONT" "drawing") list(1.05:6.09 1.27:6.31))
dbCreateRect(cvid list("CONT" "drawing") list(1.05:6.56 1.27:6.78))
dbCreateRect(cvid list("CONT" "drawing") list(1.05:7.03 1.27:7.25))
dbCreateRect(cvid list("CONT" "drawing") list(1.05:7.50 1.27:7.72))
dbCreateRect(cvid list("CONT" "drawing") list(1.05:7.97 1.27:8.19))
dbCreateRect(cvid list("CONT" "drawing") list(1.05:8.44 1.27:8.66))
dbCreateRect(cvid list("CONT" "drawing") list(1.05:8.91 1.27:9.13))
dbCreateRect(cvid list("CONT" "drawing") list(1.05:9.38 1.27:9.60))
dbCreateRect(cvid list("CONT" "drawing") list(1.05:9.85 1.27:10.07))
dbCreateRect(cvid list("CONT" "drawing") list(1.05:10.32 1.27:10.54))
dbCreateRect(cvid list("CONT" "drawing") list(1.05:10.79 1.27:11.01))
dbCreateRect(cvid list("CONT" "drawing") list(1.05:11.26 1.27:11.48))
dbCreateRect(cvid list("CONT" "drawing") list(1.05:11.73 1.27:11.95))
dbCreateRect(cvid list("CONT" "drawing") list(1.05:12.20 1.27:12.42))
dbCreateRect(cvid list("CONT" "drawing") list(1.05:12.67 1.27:12.89))
dbCreateRect(cvid list("CONT" "drawing") list(1.05:13.14 1.27:13.36))
dbCreateRect(cvid list("CONT" "drawing") list(1.05:13.61 1.27:13.83))
dbCreateRect(cvid list("CONT" "drawing") list(1.05:14.08 1.27:14.30))
dbCreateRect(cvid list("CONT" "drawing") list(1.05:14.55 1.27:14.77))
dbCreateRect(cvid list("CONT" "drawing") list(1.05:15.02 1.27:15.24))
dbCreateRect(cvid list("CONT" "drawing") list(1.05:15.49 1.27:15.71))
dbCreateRect(cvid list("CONT" "drawing") list(1.05:15.96 1.27:16.18))
dbCreateRect(cvid list("CONT" "drawing") list(1.05:16.43 1.27:16.65))
dbCreateRect(cvid list("CONT" "drawing") list(1.05:16.90 1.27:17.12))
dbCreateRect(cvid list("CONT" "drawing") list(1.05:17.37 1.27:17.59))
dbCreateRect(cvid list("CONT" "drawing") list(1.05:17.84 1.27:18.06))
dbCreateRect(cvid list("CONT" "drawing") list(1.05:18.31 1.27:18.53))
dbCreateRect(cvid list("CONT" "drawing") list(1.05:18.78 1.27:19.00))
dbCreateRect(cvid list("CONT" "drawing") list(1.05:19.25 1.27:19.47))
dbCreateRect(cvid list("CONT" "drawing") list(1.05:19.72 1.27:19.94))
dbCreateRect(cvid list("CONT" "drawing") list(1.05:20.19 1.27:20.41))
dbCreateRect(cvid list("CONT" "drawing") list(1.05:20.66 1.27:20.88))
dbCreateRect(cvid list("CONT" "drawing") list(1.05:21.13 1.27:21.35))
dbCreateRect(cvid list("CONT" "drawing") list(1.05:21.60 1.27:21.82))
dbCreateRect(cvid list("CONT" "drawing") list(1.05:22.07 1.27:22.29))
dbCreateRect(cvid list("CONT" "drawing") list(1.05:22.54 1.27:22.76))
dbCreateRect(cvid list("CONT" "drawing") list(1.05:23.01 1.27:23.23))
dbCreateRect(cvid list("CONT" "drawing") list(1.05:23.48 1.27:23.70))
dbCreateRect(cvid list("CONT" "drawing") list(1.05:23.95 1.27:24.17))
dbCreateRect(cvid list("CONT" "drawing") list(1.05:24.42 1.27:24.64))
dbCreateRect(cvid list("CONT" "drawing") list(1.05:24.89 1.27:25.11))
dbCreateRect(cvid list("CONT" "drawing") list(1.05:25.36 1.27:25.58))
dbCreateRect(cvid list("CONT" "drawing") list(1.05:25.83 1.27:26.05))
dbCreateRect(cvid list("CONT" "drawing") list(1.05:26.30 1.27:26.52))
dbCreateRect(cvid list("CONT" "drawing") list(1.05:26.77 1.27:26.99))
dbCreateRect(cvid list("CONT" "drawing") list(1.05:27.24 1.27:27.46))
dbCreateRect(cvid list("CONT" "drawing") list(1.05:27.71 1.27:27.93))
dbCreateRect(cvid list("CONT" "drawing") list(1.05:28.18 1.27:28.40))
dbCreateRect(cvid list("CONT" "drawing") list(1.05:28.65 1.27:28.87))
dbCreateRect(cvid list("CONT" "drawing") list(1.05:29.12 1.27:29.34))
dbCreateRect(cvid list("CONT" "drawing") list(1.05:29.59 1.27:29.81))
dbCreateRect(cvid list("CONT" "drawing") list(1.05:30.06 1.27:30.28))
dbCreateRect(cvid list("CONT" "drawing") list(1.05:30.53 1.27:30.75))
dbCreateRect(cvid list("CONT" "drawing") list(1.05:31.00 1.27:31.22))
dbCreateRect(cvid list("CONT" "drawing") list(1.05:31.47 1.27:31.69))
dbCreateRect(cvid list("CONT" "drawing") list(1.05:31.94 1.27:32.16))
dbCreateRect(cvid list("CONT" "drawing") list(1.05:32.41 1.27:32.63))
dbCreateRect(cvid list("CONT" "drawing") list(1.05:32.88 1.27:33.10))
dbCreateRect(cvid list("CONT" "drawing") list(1.05:33.35 1.27:33.57))
dbCreateRect(cvid list("CONT" "drawing") list(1.05:33.82 1.27:34.04))
dbCreateRect(cvid list("CONT" "drawing") list(1.05:34.29 1.27:34.51))
dbCreateRect(cvid list("CONT" "drawing") list(1.05:34.76 1.27:34.98))
dbCreateRect(cvid list("CONT" "drawing") list(1.05:35.23 1.27:35.45))
dbCreateRect(cvid list("CONT" "drawing") list(1.05:35.70 1.27:35.92))
dbCreateRect(cvid list("CONT" "drawing") list(1.05:36.17 1.27:36.39))
dbCreateRect(cvid list("CONT" "drawing") list(1.05:36.64 1.27:36.86))
dbCreateRect(cvid list("CONT" "drawing") list(1.05:37.11 1.27:37.33))
dbCreateRect(cvid list("CONT" "drawing") list(1.05:37.58 1.27:37.80))
dbCreateRect(cvid list("CONT" "drawing") list(1.05:38.05 1.27:38.27))
dbCreateRect(cvid list("CONT" "drawing") list(1.05:38.52 1.27:38.74))
dbCreateRect(cvid list("CONT" "drawing") list(1.05:38.99 1.27:39.21))
dbCreateRect(cvid list("CONT" "drawing") list(1.05:39.46 1.27:39.68))
dbCreateRect(cvid list("CONT" "drawing") list(1.05:39.93 1.27:40.15))
dbCreateRect(cvid list("CONT" "drawing") list(1.05:40.40 1.27:40.62))
dbCreateRect(cvid list("CONT" "drawing") list(1.05:40.87 1.27:41.09))
dbCreateRect(cvid list("CONT" "drawing") list(1.05:41.34 1.27:41.56))
dbCreateRect(cvid list("CONT" "drawing") list(1.05:41.81 1.27:42.03))
dbCreateRect(cvid list("CONT" "drawing") list(1.05:42.28 1.27:42.50))
dbCreateRect(cvid list("CONT" "drawing") list(1.05:42.75 1.27:42.97))
dbCreateRect(cvid list("CONT" "drawing") list(1.05:43.22 1.27:43.44))
dbCreateRect(cvid list("CONT" "drawing") list(1.05:43.69 1.27:43.91))
dbCreateRect(cvid list("CONT" "drawing") list(1.05:44.16 1.27:44.38))
dbCreateRect(cvid list("CONT" "drawing") list(1.05:44.63 1.27:44.85))
dbCreateRect(cvid list("CONT" "drawing") list(1.05:45.10 1.27:45.32))
dbCreateRect(cvid list("CONT" "drawing") list(1.05:45.57 1.27:45.79))
dbCreateRect(cvid list("CONT" "drawing") list(1.05:46.04 1.27:46.26))
dbCreateRect(cvid list("CONT" "drawing") list(1.05:46.51 1.27:46.73))
dbCreateRect(cvid list("CONT" "drawing") list(1.05:46.98 1.27:47.20))
dbCreateRect(cvid list("CONT" "drawing") list(1.05:47.45 1.27:47.67))
dbCreateRect(cvid list("CONT" "drawing") list(1.05:47.92 1.27:48.14))
dbCreateRect(cvid list("CONT" "drawing") list(1.05:48.39 1.27:48.61))
dbCreateRect(cvid list("CONT" "drawing") list(1.05:48.86 1.27:49.08))
dbCreateRect(cvid list("CONT" "drawing") list(1.05:49.33 1.27:49.55))
dbCreateRect(cvid list("CONT" "drawing") list(1.05:49.80 1.27:50.02))
dbCreateRect(cvid list("CONT" "drawing") list(1.05:50.27 1.27:50.49))
dbCreateRect(cvid list("CONT" "drawing") list(1.05:50.74 1.27:50.96))
dbCreateRect(cvid list("NIMP" "drawing") list(0.75:5.33 1.57:51.25))
dbCreateRect(cvid list("NWELL" "drawing") list(0.50:5.08 1.82:51.50))
dbCreateRect(cvid list("DIFF" "drawing") list(1.39:5.05 18.47:5.51))
dbCreateRect(cvid list("METAL1" "drawing") list(1.39:5.05 18.47:5.51))
dbCreateRect(cvid list("CONT" "drawing") list(1.83:5.17 2.05:5.39))
dbCreateRect(cvid list("CONT" "drawing") list(2.30:5.17 2.52:5.39))
dbCreateRect(cvid list("CONT" "drawing") list(2.77:5.17 2.99:5.39))
dbCreateRect(cvid list("CONT" "drawing") list(3.24:5.17 3.46:5.39))
dbCreateRect(cvid list("CONT" "drawing") list(3.71:5.17 3.93:5.39))
dbCreateRect(cvid list("CONT" "drawing") list(4.18:5.17 4.40:5.39))
dbCreateRect(cvid list("CONT" "drawing") list(4.65:5.17 4.87:5.39))
dbCreateRect(cvid list("CONT" "drawing") list(5.12:5.17 5.34:5.39))
dbCreateRect(cvid list("CONT" "drawing") list(5.59:5.17 5.81:5.39))
dbCreateRect(cvid list("CONT" "drawing") list(6.06:5.17 6.28:5.39))
dbCreateRect(cvid list("CONT" "drawing") list(6.53:5.17 6.75:5.39))
dbCreateRect(cvid list("CONT" "drawing") list(7.00:5.17 7.22:5.39))
dbCreateRect(cvid list("CONT" "drawing") list(7.47:5.17 7.69:5.39))
dbCreateRect(cvid list("CONT" "drawing") list(7.94:5.17 8.16:5.39))
dbCreateRect(cvid list("CONT" "drawing") list(8.41:5.17 8.63:5.39))
dbCreateRect(cvid list("CONT" "drawing") list(8.88:5.17 9.10:5.39))
dbCreateRect(cvid list("CONT" "drawing") list(9.35:5.17 9.57:5.39))
dbCreateRect(cvid list("CONT" "drawing") list(9.82:5.17 10.04:5.39))
dbCreateRect(cvid list("CONT" "drawing") list(10.29:5.17 10.51:5.39))
dbCreateRect(cvid list("CONT" "drawing") list(10.76:5.17 10.98:5.39))
dbCreateRect(cvid list("CONT" "drawing") list(11.23:5.17 11.45:5.39))
dbCreateRect(cvid list("CONT" "drawing") list(11.70:5.17 11.92:5.39))
dbCreateRect(cvid list("CONT" "drawing") list(12.17:5.17 12.39:5.39))
dbCreateRect(cvid list("CONT" "drawing") list(12.64:5.17 12.86:5.39))
dbCreateRect(cvid list("CONT" "drawing") list(13.11:5.17 13.33:5.39))
dbCreateRect(cvid list("CONT" "drawing") list(13.58:5.17 13.80:5.39))
dbCreateRect(cvid list("CONT" "drawing") list(14.05:5.17 14.27:5.39))
dbCreateRect(cvid list("CONT" "drawing") list(14.52:5.17 14.74:5.39))
dbCreateRect(cvid list("CONT" "drawing") list(14.99:5.17 15.21:5.39))
dbCreateRect(cvid list("CONT" "drawing") list(15.46:5.17 15.68:5.39))
dbCreateRect(cvid list("CONT" "drawing") list(15.93:5.17 16.15:5.39))
dbCreateRect(cvid list("CONT" "drawing") list(16.40:5.17 16.62:5.39))
dbCreateRect(cvid list("CONT" "drawing") list(16.87:5.17 17.09:5.39))
dbCreateRect(cvid list("CONT" "drawing") list(17.34:5.17 17.56:5.39))
dbCreateRect(cvid list("CONT" "drawing") list(17.81:5.17 18.03:5.39))
dbCreateRect(cvid list("NIMP" "drawing") list(1.21:4.87 18.65:5.69))
dbCreateRect(cvid list("NWELL" "drawing") list(0.96:4.62 18.90:5.94))
dbCreateRect(cvid list("DIFF" "drawing") list(18.47:5.51 18.93:51.07))
dbCreateRect(cvid list("METAL1" "drawing") list(18.47:5.51 18.93:51.07))
dbCreateRect(cvid list("CONT" "drawing") list(18.59:5.62 18.81:5.84))
dbCreateRect(cvid list("CONT" "drawing") list(18.59:6.09 18.81:6.31))
dbCreateRect(cvid list("CONT" "drawing") list(18.59:6.56 18.81:6.78))
dbCreateRect(cvid list("CONT" "drawing") list(18.59:7.03 18.81:7.25))
dbCreateRect(cvid list("CONT" "drawing") list(18.59:7.50 18.81:7.72))
dbCreateRect(cvid list("CONT" "drawing") list(18.59:7.97 18.81:8.19))
dbCreateRect(cvid list("CONT" "drawing") list(18.59:8.44 18.81:8.66))
dbCreateRect(cvid list("CONT" "drawing") list(18.59:8.91 18.81:9.13))
dbCreateRect(cvid list("CONT" "drawing") list(18.59:9.38 18.81:9.60))
dbCreateRect(cvid list("CONT" "drawing") list(18.59:9.85 18.81:10.07))
dbCreateRect(cvid list("CONT" "drawing") list(18.59:10.32 18.81:10.54))
dbCreateRect(cvid list("CONT" "drawing") list(18.59:10.79 18.81:11.01))
dbCreateRect(cvid list("CONT" "drawing") list(18.59:11.26 18.81:11.48))
dbCreateRect(cvid list("CONT" "drawing") list(18.59:11.73 18.81:11.95))
dbCreateRect(cvid list("CONT" "drawing") list(18.59:12.20 18.81:12.42))
dbCreateRect(cvid list("CONT" "drawing") list(18.59:12.67 18.81:12.89))
dbCreateRect(cvid list("CONT" "drawing") list(18.59:13.14 18.81:13.36))
dbCreateRect(cvid list("CONT" "drawing") list(18.59:13.61 18.81:13.83))
dbCreateRect(cvid list("CONT" "drawing") list(18.59:14.08 18.81:14.30))
dbCreateRect(cvid list("CONT" "drawing") list(18.59:14.55 18.81:14.77))
dbCreateRect(cvid list("CONT" "drawing") list(18.59:15.02 18.81:15.24))
dbCreateRect(cvid list("CONT" "drawing") list(18.59:15.49 18.81:15.71))
dbCreateRect(cvid list("CONT" "drawing") list(18.59:15.96 18.81:16.18))
dbCreateRect(cvid list("CONT" "drawing") list(18.59:16.43 18.81:16.65))
dbCreateRect(cvid list("CONT" "drawing") list(18.59:16.90 18.81:17.12))
dbCreateRect(cvid list("CONT" "drawing") list(18.59:17.37 18.81:17.59))
dbCreateRect(cvid list("CONT" "drawing") list(18.59:17.84 18.81:18.06))
dbCreateRect(cvid list("CONT" "drawing") list(18.59:18.31 18.81:18.53))
dbCreateRect(cvid list("CONT" "drawing") list(18.59:18.78 18.81:19.00))
dbCreateRect(cvid list("CONT" "drawing") list(18.59:19.25 18.81:19.47))
dbCreateRect(cvid list("CONT" "drawing") list(18.59:19.72 18.81:19.94))
dbCreateRect(cvid list("CONT" "drawing") list(18.59:20.19 18.81:20.41))
dbCreateRect(cvid list("CONT" "drawing") list(18.59:20.66 18.81:20.88))
dbCreateRect(cvid list("CONT" "drawing") list(18.59:21.13 18.81:21.35))
dbCreateRect(cvid list("CONT" "drawing") list(18.59:21.60 18.81:21.82))
dbCreateRect(cvid list("CONT" "drawing") list(18.59:22.07 18.81:22.29))
dbCreateRect(cvid list("CONT" "drawing") list(18.59:22.54 18.81:22.76))
dbCreateRect(cvid list("CONT" "drawing") list(18.59:23.01 18.81:23.23))
dbCreateRect(cvid list("CONT" "drawing") list(18.59:23.48 18.81:23.70))
dbCreateRect(cvid list("CONT" "drawing") list(18.59:23.95 18.81:24.17))
dbCreateRect(cvid list("CONT" "drawing") list(18.59:24.42 18.81:24.64))
dbCreateRect(cvid list("CONT" "drawing") list(18.59:24.89 18.81:25.11))
dbCreateRect(cvid list("CONT" "drawing") list(18.59:25.36 18.81:25.58))
dbCreateRect(cvid list("CONT" "drawing") list(18.59:25.83 18.81:26.05))
dbCreateRect(cvid list("CONT" "drawing") list(18.59:26.30 18.81:26.52))
dbCreateRect(cvid list("CONT" "drawing") list(18.59:26.77 18.81:26.99))
dbCreateRect(cvid list("CONT" "drawing") list(18.59:27.24 18.81:27.46))
dbCreateRect(cvid list("CONT" "drawing") list(18.59:27.71 18.81:27.93))
dbCreateRect(cvid list("CONT" "drawing") list(18.59:28.18 18.81:28.40))
dbCreateRect(cvid list("CONT" "drawing") list(18.59:28.65 18.81:28.87))
dbCreateRect(cvid list("CONT" "drawing") list(18.59:29.12 18.81:29.34))
dbCreateRect(cvid list("CONT" "drawing") list(18.59:29.59 18.81:29.81))
dbCreateRect(cvid list("CONT" "drawing") list(18.59:30.06 18.81:30.28))
dbCreateRect(cvid list("CONT" "drawing") list(18.59:30.53 18.81:30.75))
dbCreateRect(cvid list("CONT" "drawing") list(18.59:31.00 18.81:31.22))
dbCreateRect(cvid list("CONT" "drawing") list(18.59:31.47 18.81:31.69))
dbCreateRect(cvid list("CONT" "drawing") list(18.59:31.94 18.81:32.16))
dbCreateRect(cvid list("CONT" "drawing") list(18.59:32.41 18.81:32.63))
dbCreateRect(cvid list("CONT" "drawing") list(18.59:32.88 18.81:33.10))
dbCreateRect(cvid list("CONT" "drawing") list(18.59:33.35 18.81:33.57))
dbCreateRect(cvid list("CONT" "drawing") list(18.59:33.82 18.81:34.04))
dbCreateRect(cvid list("CONT" "drawing") list(18.59:34.29 18.81:34.51))
dbCreateRect(cvid list("CONT" "drawing") list(18.59:34.76 18.81:34.98))
dbCreateRect(cvid list("CONT" "drawing") list(18.59:35.23 18.81:35.45))
dbCreateRect(cvid list("CONT" "drawing") list(18.59:35.70 18.81:35.92))
dbCreateRect(cvid list("CONT" "drawing") list(18.59:36.17 18.81:36.39))
dbCreateRect(cvid list("CONT" "drawing") list(18.59:36.64 18.81:36.86))
dbCreateRect(cvid list("CONT" "drawing") list(18.59:37.11 18.81:37.33))
dbCreateRect(cvid list("CONT" "drawing") list(18.59:37.58 18.81:37.80))
dbCreateRect(cvid list("CONT" "drawing") list(18.59:38.05 18.81:38.27))
dbCreateRect(cvid list("CONT" "drawing") list(18.59:38.52 18.81:38.74))
dbCreateRect(cvid list("CONT" "drawing") list(18.59:38.99 18.81:39.21))
dbCreateRect(cvid list("CONT" "drawing") list(18.59:39.46 18.81:39.68))
dbCreateRect(cvid list("CONT" "drawing") list(18.59:39.93 18.81:40.15))
dbCreateRect(cvid list("CONT" "drawing") list(18.59:40.40 18.81:40.62))
dbCreateRect(cvid list("CONT" "drawing") list(18.59:40.87 18.81:41.09))
dbCreateRect(cvid list("CONT" "drawing") list(18.59:41.34 18.81:41.56))
dbCreateRect(cvid list("CONT" "drawing") list(18.59:41.81 18.81:42.03))
dbCreateRect(cvid list("CONT" "drawing") list(18.59:42.28 18.81:42.50))
dbCreateRect(cvid list("CONT" "drawing") list(18.59:42.75 18.81:42.97))
dbCreateRect(cvid list("CONT" "drawing") list(18.59:43.22 18.81:43.44))
dbCreateRect(cvid list("CONT" "drawing") list(18.59:43.69 18.81:43.91))
dbCreateRect(cvid list("CONT" "drawing") list(18.59:44.16 18.81:44.38))
dbCreateRect(cvid list("CONT" "drawing") list(18.59:44.63 18.81:44.85))
dbCreateRect(cvid list("CONT" "drawing") list(18.59:45.10 18.81:45.32))
dbCreateRect(cvid list("CONT" "drawing") list(18.59:45.57 18.81:45.79))
dbCreateRect(cvid list("CONT" "drawing") list(18.59:46.04 18.81:46.26))
dbCreateRect(cvid list("CONT" "drawing") list(18.59:46.51 18.81:46.73))
dbCreateRect(cvid list("CONT" "drawing") list(18.59:46.98 18.81:47.20))
dbCreateRect(cvid list("CONT" "drawing") list(18.59:47.45 18.81:47.67))
dbCreateRect(cvid list("CONT" "drawing") list(18.59:47.92 18.81:48.14))
dbCreateRect(cvid list("CONT" "drawing") list(18.59:48.39 18.81:48.61))
dbCreateRect(cvid list("CONT" "drawing") list(18.59:48.86 18.81:49.08))
dbCreateRect(cvid list("CONT" "drawing") list(18.59:49.33 18.81:49.55))
dbCreateRect(cvid list("CONT" "drawing") list(18.59:49.80 18.81:50.02))
dbCreateRect(cvid list("CONT" "drawing") list(18.59:50.27 18.81:50.49))
dbCreateRect(cvid list("CONT" "drawing") list(18.59:50.74 18.81:50.96))
dbCreateRect(cvid list("NIMP" "drawing") list(18.29:5.33 19.11:51.25))
dbCreateRect(cvid list("NWELL" "drawing") list(18.04:5.08 19.36:51.50))
dbCreateRect(cvid list("DIFF" "drawing") list(1.39:51.07 18.47:51.53))
dbCreateRect(cvid list("METAL1" "drawing") list(1.39:51.07 18.47:51.53))
dbCreateRect(cvid list("CONT" "drawing") list(1.83:51.19 2.05:51.41))
dbCreateRect(cvid list("CONT" "drawing") list(2.30:51.19 2.52:51.41))
dbCreateRect(cvid list("CONT" "drawing") list(2.77:51.19 2.99:51.41))
dbCreateRect(cvid list("CONT" "drawing") list(3.24:51.19 3.46:51.41))
dbCreateRect(cvid list("CONT" "drawing") list(3.71:51.19 3.93:51.41))
dbCreateRect(cvid list("CONT" "drawing") list(4.18:51.19 4.40:51.41))
dbCreateRect(cvid list("CONT" "drawing") list(4.65:51.19 4.87:51.41))
dbCreateRect(cvid list("CONT" "drawing") list(5.12:51.19 5.34:51.41))
dbCreateRect(cvid list("CONT" "drawing") list(5.59:51.19 5.81:51.41))
dbCreateRect(cvid list("CONT" "drawing") list(6.06:51.19 6.28:51.41))
dbCreateRect(cvid list("CONT" "drawing") list(6.53:51.19 6.75:51.41))
dbCreateRect(cvid list("CONT" "drawing") list(7.00:51.19 7.22:51.41))
dbCreateRect(cvid list("CONT" "drawing") list(7.47:51.19 7.69:51.41))
dbCreateRect(cvid list("CONT" "drawing") list(7.94:51.19 8.16:51.41))
dbCreateRect(cvid list("CONT" "drawing") list(8.41:51.19 8.63:51.41))
dbCreateRect(cvid list("CONT" "drawing") list(8.88:51.19 9.10:51.41))
dbCreateRect(cvid list("CONT" "drawing") list(9.35:51.19 9.57:51.41))
dbCreateRect(cvid list("CONT" "drawing") list(9.82:51.19 10.04:51.41))
dbCreateRect(cvid list("CONT" "drawing") list(10.29:51.19 10.51:51.41))
dbCreateRect(cvid list("CONT" "drawing") list(10.76:51.19 10.98:51.41))
dbCreateRect(cvid list("CONT" "drawing") list(11.23:51.19 11.45:51.41))
dbCreateRect(cvid list("CONT" "drawing") list(11.70:51.19 11.92:51.41))
dbCreateRect(cvid list("CONT" "drawing") list(12.17:51.19 12.39:51.41))
dbCreateRect(cvid list("CONT" "drawing") list(12.64:51.19 12.86:51.41))
dbCreateRect(cvid list("CONT" "drawing") list(13.11:51.19 13.33:51.41))
dbCreateRect(cvid list("CONT" "drawing") list(13.58:51.19 13.80:51.41))
dbCreateRect(cvid list("CONT" "drawing") list(14.05:51.19 14.27:51.41))
dbCreateRect(cvid list("CONT" "drawing") list(14.52:51.19 14.74:51.41))
dbCreateRect(cvid list("CONT" "drawing") list(14.99:51.19 15.21:51.41))
dbCreateRect(cvid list("CONT" "drawing") list(15.46:51.19 15.68:51.41))
dbCreateRect(cvid list("CONT" "drawing") list(15.93:51.19 16.15:51.41))
dbCreateRect(cvid list("CONT" "drawing") list(16.40:51.19 16.62:51.41))
dbCreateRect(cvid list("CONT" "drawing") list(16.87:51.19 17.09:51.41))
dbCreateRect(cvid list("CONT" "drawing") list(17.34:51.19 17.56:51.41))
dbCreateRect(cvid list("CONT" "drawing") list(17.81:51.19 18.03:51.41))
dbCreateRect(cvid list("NIMP" "drawing") list(1.21:50.89 18.65:51.71))
dbCreateRect(cvid list("NWELL" "drawing") list(0.96:50.64 18.90:51.96))
dbCreateParamInst(cvid masterpmos "I13" list(85.300 67.670) "MY" 1 list(list("w" "string" "10.00u") list("l" "string" "1.00u") ))
dbCreateParamInst(cvid masterpmos "M14.3" list(85.840 67.670) "R0" 1 list(list("w" "string" "10.00u") list("l" "string" "1.00u") ))
dbCreateParamInst(cvid masterpmos "M14.4" list(88.380 67.670) "MY" 1 list(list("w" "string" "10.00u") list("l" "string" "1.00u") ))
dbCreateParamInst(cvid masterpmos "M13.3" list(88.920 67.670) "R0" 1 list(list("w" "string" "10.00u") list("l" "string" "1.00u") ))
dbCreateParamInst(cvid masterpmos "M13.4" list(91.460 67.670) "MY" 1 list(list("w" "string" "10.00u") list("l" "string" "1.00u") ))
dbCreateParamInst(cvid masterpmos "I12" list(92.000 67.670) "R0" 1 list(list("w" "string" "10.00u") list("l" "string" "1.00u") ))
dbCreateRect(cvid list("METAL1" "drawing") list(83.83:67.67 84.23:77.67))
dbCreateRect(cvid list("METAL1" "drawing") list(85.37:67.67 85.77:77.67))
dbCreateRect(cvid list("METAL1" "drawing") list(86.91:67.67 87.31:77.67))
dbCreateRect(cvid list("METAL1" "drawing") list(88.45:67.67 88.85:77.67))
dbCreateRect(cvid list("METAL1" "drawing") list(89.99:67.67 90.39:77.67))
dbCreateRect(cvid list("METAL1" "drawing") list(91.53:67.67 91.93:77.67))
dbCreateRect(cvid list("METAL1" "drawing") list(93.07:67.67 93.47:77.67))
dbCreateRect(cvid list("POLY1" "drawing") list(84.30:67.03 85.30:67.45))
dbCreateRect(cvid list("METAL1" "drawing") list(84.42:67.03 85.17:67.45))
dbCreateRect(cvid list("CONT" "drawing") list(84.69:67.13 84.91:67.35))
dbCreateRect(cvid list("POLY1" "drawing") list(85.84:67.03 86.84:67.45))
dbCreateRect(cvid list("METAL1" "drawing") list(85.96:67.03 86.71:67.45))
dbCreateRect(cvid list("CONT" "drawing") list(86.23:67.13 86.45:67.35))
dbCreateRect(cvid list("POLY1" "drawing") list(87.38:67.03 88.38:67.45))
dbCreateRect(cvid list("METAL1" "drawing") list(87.50:67.03 88.25:67.45))
dbCreateRect(cvid list("CONT" "drawing") list(87.77:67.13 87.99:67.35))
dbCreateRect(cvid list("POLY1" "drawing") list(88.92:67.03 89.92:67.45))
dbCreateRect(cvid list("METAL1" "drawing") list(89.04:67.03 89.79:67.45))
dbCreateRect(cvid list("CONT" "drawing") list(89.31:67.13 89.53:67.35))
dbCreateRect(cvid list("POLY1" "drawing") list(90.46:67.03 91.46:67.45))
dbCreateRect(cvid list("METAL1" "drawing") list(90.58:67.03 91.33:67.45))
dbCreateRect(cvid list("CONT" "drawing") list(90.85:67.13 91.07:67.35))
dbCreateRect(cvid list("POLY1" "drawing") list(92.00:67.03 93.00:67.45))
dbCreateRect(cvid list("METAL1" "drawing") list(92.12:67.03 92.88:67.45))
dbCreateRect(cvid list("CONT" "drawing") list(92.39:67.13 92.61:67.35))
dbCreateParamInst(cvid masterpmos "I15" list(85.300 55.410) "MY" 1 list(list("w" "string" "10.00u") list("l" "string" "1.00u") ))
dbCreateParamInst(cvid masterpmos "M14.1" list(85.840 55.410) "R0" 1 list(list("w" "string" "10.00u") list("l" "string" "1.00u") ))
dbCreateParamInst(cvid masterpmos "M14.2" list(88.380 55.410) "MY" 1 list(list("w" "string" "10.00u") list("l" "string" "1.00u") ))
dbCreateParamInst(cvid masterpmos "M13.1" list(88.920 55.410) "R0" 1 list(list("w" "string" "10.00u") list("l" "string" "1.00u") ))
dbCreateParamInst(cvid masterpmos "M13.2" list(91.460 55.410) "MY" 1 list(list("w" "string" "10.00u") list("l" "string" "1.00u") ))
dbCreateParamInst(cvid masterpmos "I14" list(92.000 55.410) "R0" 1 list(list("w" "string" "10.00u") list("l" "string" "1.00u") ))
dbCreateRect(cvid list("METAL1" "drawing") list(83.83:55.41 84.23:65.41))
dbCreateRect(cvid list("METAL1" "drawing") list(85.37:55.41 85.77:65.41))
dbCreateRect(cvid list("METAL1" "drawing") list(86.91:55.41 87.31:65.41))
dbCreateRect(cvid list("METAL1" "drawing") list(88.45:55.41 88.85:65.41))
dbCreateRect(cvid list("METAL1" "drawing") list(89.99:55.41 90.39:65.41))
dbCreateRect(cvid list("METAL1" "drawing") list(91.53:55.41 91.93:65.41))
dbCreateRect(cvid list("METAL1" "drawing") list(93.07:55.41 93.47:65.41))
dbCreateRect(cvid list("POLY1" "drawing") list(84.30:65.63 85.30:66.05))
dbCreateRect(cvid list("METAL1" "drawing") list(84.42:65.63 85.17:66.05))
dbCreateRect(cvid list("CONT" "drawing") list(84.69:65.73 84.91:65.95))
dbCreateRect(cvid list("POLY1" "drawing") list(85.84:65.63 86.84:66.05))
dbCreateRect(cvid list("METAL1" "drawing") list(85.96:65.63 86.71:66.05))
dbCreateRect(cvid list("CONT" "drawing") list(86.23:65.73 86.45:65.95))
dbCreateRect(cvid list("POLY1" "drawing") list(87.38:65.63 88.38:66.05))
dbCreateRect(cvid list("METAL1" "drawing") list(87.50:65.63 88.25:66.05))
dbCreateRect(cvid list("CONT" "drawing") list(87.77:65.73 87.99:65.95))
dbCreateRect(cvid list("POLY1" "drawing") list(88.92:65.63 89.92:66.05))
dbCreateRect(cvid list("METAL1" "drawing") list(89.04:65.63 89.79:66.05))
dbCreateRect(cvid list("CONT" "drawing") list(89.31:65.73 89.53:65.95))
dbCreateRect(cvid list("POLY1" "drawing") list(90.46:65.63 91.46:66.05))
dbCreateRect(cvid list("METAL1" "drawing") list(90.58:65.63 91.33:66.05))
dbCreateRect(cvid list("CONT" "drawing") list(90.85:65.73 91.07:65.95))
dbCreateRect(cvid list("POLY1" "drawing") list(92.00:65.63 93.00:66.05))
dbCreateRect(cvid list("METAL1" "drawing") list(92.12:65.63 92.88:66.05))
dbCreateRect(cvid list("CONT" "drawing") list(92.39:65.73 92.61:65.95))
dbCreateRect(cvid list("DIFF" "drawing") list(83.07:54.24 83.53:54.70))
dbCreateRect(cvid list("METAL1" "drawing") list(83.07:54.24 83.53:54.70))
dbCreateRect(cvid list("CONT" "drawing") list(83.19:54.36 83.41:54.58))
dbCreateRect(cvid list("NIMP" "drawing") list(82.89:54.06 83.71:54.88))
dbCreateRect(cvid list("NWELL" "drawing") list(82.64:53.81 83.96:55.13))
dbCreateRect(cvid list("DIFF" "drawing") list(93.77:54.24 94.23:54.70))
dbCreateRect(cvid list("METAL1" "drawing") list(93.77:54.24 94.23:54.70))
dbCreateRect(cvid list("CONT" "drawing") list(93.89:54.36 94.11:54.58))
dbCreateRect(cvid list("NIMP" "drawing") list(93.59:54.06 94.41:54.88))
dbCreateRect(cvid list("NWELL" "drawing") list(93.34:53.81 94.66:55.13))
dbCreateRect(cvid list("DIFF" "drawing") list(83.07:78.38 83.53:78.84))
dbCreateRect(cvid list("METAL1" "drawing") list(83.07:78.38 83.53:78.84))
dbCreateRect(cvid list("CONT" "drawing") list(83.19:78.50 83.41:78.72))
dbCreateRect(cvid list("NIMP" "drawing") list(82.89:78.20 83.71:79.02))
dbCreateRect(cvid list("NWELL" "drawing") list(82.64:77.95 83.96:79.27))
dbCreateRect(cvid list("DIFF" "drawing") list(93.77:78.38 94.23:78.84))
dbCreateRect(cvid list("METAL1" "drawing") list(93.77:78.38 94.23:78.84))
dbCreateRect(cvid list("CONT" "drawing") list(93.89:78.50 94.11:78.72))
dbCreateRect(cvid list("NIMP" "drawing") list(93.59:78.20 94.41:79.02))
dbCreateRect(cvid list("NWELL" "drawing") list(93.34:77.95 94.66:79.27))
dbCreateRect(cvid list("DIFF" "drawing") list(83.07:54.70 83.53:78.38))
dbCreateRect(cvid list("METAL1" "drawing") list(83.07:54.70 83.53:78.38))
dbCreateRect(cvid list("CONT" "drawing") list(83.19:55.15 83.41:55.37))
dbCreateRect(cvid list("CONT" "drawing") list(83.19:55.62 83.41:55.84))
dbCreateRect(cvid list("CONT" "drawing") list(83.19:56.09 83.41:56.31))
dbCreateRect(cvid list("CONT" "drawing") list(83.19:56.56 83.41:56.78))
dbCreateRect(cvid list("CONT" "drawing") list(83.19:57.03 83.41:57.25))
dbCreateRect(cvid list("CONT" "drawing") list(83.19:57.50 83.41:57.72))
dbCreateRect(cvid list("CONT" "drawing") list(83.19:57.97 83.41:58.19))
dbCreateRect(cvid list("CONT" "drawing") list(83.19:58.44 83.41:58.66))
dbCreateRect(cvid list("CONT" "drawing") list(83.19:58.91 83.41:59.13))
dbCreateRect(cvid list("CONT" "drawing") list(83.19:59.38 83.41:59.60))
dbCreateRect(cvid list("CONT" "drawing") list(83.19:59.85 83.41:60.07))
dbCreateRect(cvid list("CONT" "drawing") list(83.19:60.32 83.41:60.54))
dbCreateRect(cvid list("CONT" "drawing") list(83.19:60.79 83.41:61.01))
dbCreateRect(cvid list("CONT" "drawing") list(83.19:61.26 83.41:61.48))
dbCreateRect(cvid list("CONT" "drawing") list(83.19:61.73 83.41:61.95))
dbCreateRect(cvid list("CONT" "drawing") list(83.19:62.20 83.41:62.42))
dbCreateRect(cvid list("CONT" "drawing") list(83.19:62.67 83.41:62.89))
dbCreateRect(cvid list("CONT" "drawing") list(83.19:63.14 83.41:63.36))
dbCreateRect(cvid list("CONT" "drawing") list(83.19:63.61 83.41:63.83))
dbCreateRect(cvid list("CONT" "drawing") list(83.19:64.08 83.41:64.30))
dbCreateRect(cvid list("CONT" "drawing") list(83.19:64.55 83.41:64.77))
dbCreateRect(cvid list("CONT" "drawing") list(83.19:65.02 83.41:65.24))
dbCreateRect(cvid list("CONT" "drawing") list(83.19:65.49 83.41:65.71))
dbCreateRect(cvid list("CONT" "drawing") list(83.19:65.96 83.41:66.18))
dbCreateRect(cvid list("CONT" "drawing") list(83.19:66.43 83.41:66.65))
dbCreateRect(cvid list("CONT" "drawing") list(83.19:66.90 83.41:67.12))
dbCreateRect(cvid list("CONT" "drawing") list(83.19:67.37 83.41:67.59))
dbCreateRect(cvid list("CONT" "drawing") list(83.19:67.84 83.41:68.06))
dbCreateRect(cvid list("CONT" "drawing") list(83.19:68.31 83.41:68.53))
dbCreateRect(cvid list("CONT" "drawing") list(83.19:68.78 83.41:69.00))
dbCreateRect(cvid list("CONT" "drawing") list(83.19:69.25 83.41:69.47))
dbCreateRect(cvid list("CONT" "drawing") list(83.19:69.72 83.41:69.94))
dbCreateRect(cvid list("CONT" "drawing") list(83.19:70.19 83.41:70.41))
dbCreateRect(cvid list("CONT" "drawing") list(83.19:70.66 83.41:70.88))
dbCreateRect(cvid list("CONT" "drawing") list(83.19:71.13 83.41:71.35))
dbCreateRect(cvid list("CONT" "drawing") list(83.19:71.60 83.41:71.82))
dbCreateRect(cvid list("CONT" "drawing") list(83.19:72.07 83.41:72.29))
dbCreateRect(cvid list("CONT" "drawing") list(83.19:72.54 83.41:72.76))
dbCreateRect(cvid list("CONT" "drawing") list(83.19:73.01 83.41:73.23))
dbCreateRect(cvid list("CONT" "drawing") list(83.19:73.48 83.41:73.70))
dbCreateRect(cvid list("CONT" "drawing") list(83.19:73.95 83.41:74.17))
dbCreateRect(cvid list("CONT" "drawing") list(83.19:74.42 83.41:74.64))
dbCreateRect(cvid list("CONT" "drawing") list(83.19:74.89 83.41:75.11))
dbCreateRect(cvid list("CONT" "drawing") list(83.19:75.36 83.41:75.58))
dbCreateRect(cvid list("CONT" "drawing") list(83.19:75.83 83.41:76.05))
dbCreateRect(cvid list("CONT" "drawing") list(83.19:76.30 83.41:76.52))
dbCreateRect(cvid list("CONT" "drawing") list(83.19:76.77 83.41:76.99))
dbCreateRect(cvid list("CONT" "drawing") list(83.19:77.24 83.41:77.46))
dbCreateRect(cvid list("CONT" "drawing") list(83.19:77.71 83.41:77.93))
dbCreateRect(cvid list("NIMP" "drawing") list(82.89:54.52 83.71:78.56))
dbCreateRect(cvid list("NWELL" "drawing") list(82.64:54.27 83.96:78.81))
dbCreateRect(cvid list("DIFF" "drawing") list(83.53:54.24 93.77:54.70))
dbCreateRect(cvid list("METAL1" "drawing") list(83.53:54.24 93.77:54.70))
dbCreateRect(cvid list("CONT" "drawing") list(83.84:54.36 84.06:54.58))
dbCreateRect(cvid list("CONT" "drawing") list(84.31:54.36 84.53:54.58))
dbCreateRect(cvid list("CONT" "drawing") list(84.78:54.36 85.00:54.58))
dbCreateRect(cvid list("CONT" "drawing") list(85.25:54.36 85.47:54.58))
dbCreateRect(cvid list("CONT" "drawing") list(85.72:54.36 85.94:54.58))
dbCreateRect(cvid list("CONT" "drawing") list(86.19:54.36 86.41:54.58))
dbCreateRect(cvid list("CONT" "drawing") list(86.66:54.36 86.88:54.58))
dbCreateRect(cvid list("CONT" "drawing") list(87.13:54.36 87.35:54.58))
dbCreateRect(cvid list("CONT" "drawing") list(87.60:54.36 87.82:54.58))
dbCreateRect(cvid list("CONT" "drawing") list(88.07:54.36 88.29:54.58))
dbCreateRect(cvid list("CONT" "drawing") list(88.54:54.36 88.76:54.58))
dbCreateRect(cvid list("CONT" "drawing") list(89.01:54.36 89.23:54.58))
dbCreateRect(cvid list("CONT" "drawing") list(89.48:54.36 89.70:54.58))
dbCreateRect(cvid list("CONT" "drawing") list(89.95:54.36 90.17:54.58))
dbCreateRect(cvid list("CONT" "drawing") list(90.42:54.36 90.64:54.58))
dbCreateRect(cvid list("CONT" "drawing") list(90.89:54.36 91.11:54.58))
dbCreateRect(cvid list("CONT" "drawing") list(91.36:54.36 91.58:54.58))
dbCreateRect(cvid list("CONT" "drawing") list(91.83:54.36 92.05:54.58))
dbCreateRect(cvid list("CONT" "drawing") list(92.30:54.36 92.52:54.58))
dbCreateRect(cvid list("CONT" "drawing") list(92.77:54.36 92.99:54.58))
dbCreateRect(cvid list("CONT" "drawing") list(93.24:54.36 93.46:54.58))
dbCreateRect(cvid list("NIMP" "drawing") list(83.35:54.06 93.95:54.88))
dbCreateRect(cvid list("NWELL" "drawing") list(83.10:53.81 94.20:55.13))
dbCreateRect(cvid list("DIFF" "drawing") list(93.77:54.70 94.23:78.38))
dbCreateRect(cvid list("METAL1" "drawing") list(93.77:54.70 94.23:78.38))
dbCreateRect(cvid list("CONT" "drawing") list(93.89:55.15 94.11:55.37))
dbCreateRect(cvid list("CONT" "drawing") list(93.89:55.62 94.11:55.84))
dbCreateRect(cvid list("CONT" "drawing") list(93.89:56.09 94.11:56.31))
dbCreateRect(cvid list("CONT" "drawing") list(93.89:56.56 94.11:56.78))
dbCreateRect(cvid list("CONT" "drawing") list(93.89:57.03 94.11:57.25))
dbCreateRect(cvid list("CONT" "drawing") list(93.89:57.50 94.11:57.72))
dbCreateRect(cvid list("CONT" "drawing") list(93.89:57.97 94.11:58.19))
dbCreateRect(cvid list("CONT" "drawing") list(93.89:58.44 94.11:58.66))
dbCreateRect(cvid list("CONT" "drawing") list(93.89:58.91 94.11:59.13))
dbCreateRect(cvid list("CONT" "drawing") list(93.89:59.38 94.11:59.60))
dbCreateRect(cvid list("CONT" "drawing") list(93.89:59.85 94.11:60.07))
dbCreateRect(cvid list("CONT" "drawing") list(93.89:60.32 94.11:60.54))
dbCreateRect(cvid list("CONT" "drawing") list(93.89:60.79 94.11:61.01))
dbCreateRect(cvid list("CONT" "drawing") list(93.89:61.26 94.11:61.48))
dbCreateRect(cvid list("CONT" "drawing") list(93.89:61.73 94.11:61.95))
dbCreateRect(cvid list("CONT" "drawing") list(93.89:62.20 94.11:62.42))
dbCreateRect(cvid list("CONT" "drawing") list(93.89:62.67 94.11:62.89))
dbCreateRect(cvid list("CONT" "drawing") list(93.89:63.14 94.11:63.36))
dbCreateRect(cvid list("CONT" "drawing") list(93.89:63.61 94.11:63.83))
dbCreateRect(cvid list("CONT" "drawing") list(93.89:64.08 94.11:64.30))
dbCreateRect(cvid list("CONT" "drawing") list(93.89:64.55 94.11:64.77))
dbCreateRect(cvid list("CONT" "drawing") list(93.89:65.02 94.11:65.24))
dbCreateRect(cvid list("CONT" "drawing") list(93.89:65.49 94.11:65.71))
dbCreateRect(cvid list("CONT" "drawing") list(93.89:65.96 94.11:66.18))
dbCreateRect(cvid list("CONT" "drawing") list(93.89:66.43 94.11:66.65))
dbCreateRect(cvid list("CONT" "drawing") list(93.89:66.90 94.11:67.12))
dbCreateRect(cvid list("CONT" "drawing") list(93.89:67.37 94.11:67.59))
dbCreateRect(cvid list("CONT" "drawing") list(93.89:67.84 94.11:68.06))
dbCreateRect(cvid list("CONT" "drawing") list(93.89:68.31 94.11:68.53))
dbCreateRect(cvid list("CONT" "drawing") list(93.89:68.78 94.11:69.00))
dbCreateRect(cvid list("CONT" "drawing") list(93.89:69.25 94.11:69.47))
dbCreateRect(cvid list("CONT" "drawing") list(93.89:69.72 94.11:69.94))
dbCreateRect(cvid list("CONT" "drawing") list(93.89:70.19 94.11:70.41))
dbCreateRect(cvid list("CONT" "drawing") list(93.89:70.66 94.11:70.88))
dbCreateRect(cvid list("CONT" "drawing") list(93.89:71.13 94.11:71.35))
dbCreateRect(cvid list("CONT" "drawing") list(93.89:71.60 94.11:71.82))
dbCreateRect(cvid list("CONT" "drawing") list(93.89:72.07 94.11:72.29))
dbCreateRect(cvid list("CONT" "drawing") list(93.89:72.54 94.11:72.76))
dbCreateRect(cvid list("CONT" "drawing") list(93.89:73.01 94.11:73.23))
dbCreateRect(cvid list("CONT" "drawing") list(93.89:73.48 94.11:73.70))
dbCreateRect(cvid list("CONT" "drawing") list(93.89:73.95 94.11:74.17))
dbCreateRect(cvid list("CONT" "drawing") list(93.89:74.42 94.11:74.64))
dbCreateRect(cvid list("CONT" "drawing") list(93.89:74.89 94.11:75.11))
dbCreateRect(cvid list("CONT" "drawing") list(93.89:75.36 94.11:75.58))
dbCreateRect(cvid list("CONT" "drawing") list(93.89:75.83 94.11:76.05))
dbCreateRect(cvid list("CONT" "drawing") list(93.89:76.30 94.11:76.52))
dbCreateRect(cvid list("CONT" "drawing") list(93.89:76.77 94.11:76.99))
dbCreateRect(cvid list("CONT" "drawing") list(93.89:77.24 94.11:77.46))
dbCreateRect(cvid list("CONT" "drawing") list(93.89:77.71 94.11:77.93))
dbCreateRect(cvid list("NIMP" "drawing") list(93.59:54.52 94.41:78.56))
dbCreateRect(cvid list("NWELL" "drawing") list(93.34:54.27 94.66:78.81))
dbCreateRect(cvid list("DIFF" "drawing") list(83.53:78.38 93.77:78.84))
dbCreateRect(cvid list("METAL1" "drawing") list(83.53:78.38 93.77:78.84))
dbCreateRect(cvid list("CONT" "drawing") list(83.84:78.50 84.06:78.72))
dbCreateRect(cvid list("CONT" "drawing") list(84.31:78.50 84.53:78.72))
dbCreateRect(cvid list("CONT" "drawing") list(84.78:78.50 85.00:78.72))
dbCreateRect(cvid list("CONT" "drawing") list(85.25:78.50 85.47:78.72))
dbCreateRect(cvid list("CONT" "drawing") list(85.72:78.50 85.94:78.72))
dbCreateRect(cvid list("CONT" "drawing") list(86.19:78.50 86.41:78.72))
dbCreateRect(cvid list("CONT" "drawing") list(86.66:78.50 86.88:78.72))
dbCreateRect(cvid list("CONT" "drawing") list(87.13:78.50 87.35:78.72))
dbCreateRect(cvid list("CONT" "drawing") list(87.60:78.50 87.82:78.72))
dbCreateRect(cvid list("CONT" "drawing") list(88.07:78.50 88.29:78.72))
dbCreateRect(cvid list("CONT" "drawing") list(88.54:78.50 88.76:78.72))
dbCreateRect(cvid list("CONT" "drawing") list(89.01:78.50 89.23:78.72))
dbCreateRect(cvid list("CONT" "drawing") list(89.48:78.50 89.70:78.72))
dbCreateRect(cvid list("CONT" "drawing") list(89.95:78.50 90.17:78.72))
dbCreateRect(cvid list("CONT" "drawing") list(90.42:78.50 90.64:78.72))
dbCreateRect(cvid list("CONT" "drawing") list(90.89:78.50 91.11:78.72))
dbCreateRect(cvid list("CONT" "drawing") list(91.36:78.50 91.58:78.72))
dbCreateRect(cvid list("CONT" "drawing") list(91.83:78.50 92.05:78.72))
dbCreateRect(cvid list("CONT" "drawing") list(92.30:78.50 92.52:78.72))
dbCreateRect(cvid list("CONT" "drawing") list(92.77:78.50 92.99:78.72))
dbCreateRect(cvid list("CONT" "drawing") list(93.24:78.50 93.46:78.72))
dbCreateRect(cvid list("NIMP" "drawing") list(83.35:78.20 93.95:79.02))
dbCreateRect(cvid list("NWELL" "drawing") list(83.10:77.95 94.20:79.27))
dbCreateParamInst(cvid masternmos "M15.1" list(81.785 4.500) "R0" 1 list(list("w" "string" "10.00u") list("l" "string" "1.00u") ))
dbCreateParamInst(cvid masternmos "M15.4" list(84.325 4.500) "MY" 1 list(list("w" "string" "10.00u") list("l" "string" "1.00u") ))
dbCreateParamInst(cvid masternmos "M15.3" list(84.865 4.500) "R0" 1 list(list("w" "string" "10.00u") list("l" "string" "1.00u") ))
dbCreateParamInst(cvid masternmos "M15.2" list(87.405 4.500) "MY" 1 list(list("w" "string" "10.00u") list("l" "string" "1.00u") ))
dbCreateParamInst(cvid masternmos "M15.5" list(87.945 4.500) "R0" 1 list(list("w" "string" "10.00u") list("l" "string" "1.00u") ))
dbCreateParamInst(cvid masternmos "M15.6" list(90.485 4.500) "MY" 1 list(list("w" "string" "10.00u") list("l" "string" "1.00u") ))
dbCreateParamInst(cvid masternmos "M15.7" list(91.025 4.500) "R0" 1 list(list("w" "string" "10.00u") list("l" "string" "1.00u") ))
dbCreateParamInst(cvid masternmos "M15.8" list(93.565 4.500) "MY" 1 list(list("w" "string" "10.00u") list("l" "string" "1.00u") ))
dbCreateRect(cvid list("METAL1" "drawing") list(81.31:4.50 81.71:14.50))
dbCreateRect(cvid list("METAL1" "drawing") list(82.85:4.50 83.25:14.50))
dbCreateRect(cvid list("METAL1" "drawing") list(84.39:4.50 84.79:14.50))
dbCreateRect(cvid list("METAL1" "drawing") list(85.93:4.50 86.33:14.50))
dbCreateRect(cvid list("METAL1" "drawing") list(87.47:4.50 87.87:14.50))
dbCreateRect(cvid list("METAL1" "drawing") list(89.01:4.50 89.41:14.50))
dbCreateRect(cvid list("METAL1" "drawing") list(90.55:4.50 90.95:14.50))
dbCreateRect(cvid list("METAL1" "drawing") list(92.09:4.50 92.49:14.50))
dbCreateRect(cvid list("METAL1" "drawing") list(93.64:4.50 94.04:14.50))
dbCreateRect(cvid list("POLY1" "drawing") list(81.78:14.72 82.78:15.14))
dbCreateRect(cvid list("METAL1" "drawing") list(81.91:14.72 82.66:15.14))
dbCreateRect(cvid list("CONT" "drawing") list(82.17:14.82 82.39:15.04))
dbCreateRect(cvid list("POLY1" "drawing") list(83.32:14.72 84.32:15.14))
dbCreateRect(cvid list("METAL1" "drawing") list(83.45:14.72 84.20:15.14))
dbCreateRect(cvid list("CONT" "drawing") list(83.71:14.82 83.93:15.04))
dbCreateRect(cvid list("POLY1" "drawing") list(84.86:14.72 85.86:15.14))
dbCreateRect(cvid list("METAL1" "drawing") list(84.99:14.72 85.74:15.14))
dbCreateRect(cvid list("CONT" "drawing") list(85.25:14.82 85.47:15.04))
dbCreateRect(cvid list("POLY1" "drawing") list(86.40:14.72 87.40:15.14))
dbCreateRect(cvid list("METAL1" "drawing") list(86.53:14.72 87.28:15.14))
dbCreateRect(cvid list("CONT" "drawing") list(86.79:14.82 87.01:15.04))
dbCreateRect(cvid list("POLY1" "drawing") list(87.94:14.72 88.94:15.14))
dbCreateRect(cvid list("METAL1" "drawing") list(88.07:14.72 88.82:15.14))
dbCreateRect(cvid list("CONT" "drawing") list(88.33:14.82 88.55:15.04))
dbCreateRect(cvid list("POLY1" "drawing") list(89.48:14.72 90.48:15.14))
dbCreateRect(cvid list("METAL1" "drawing") list(89.61:14.72 90.36:15.14))
dbCreateRect(cvid list("CONT" "drawing") list(89.87:14.82 90.09:15.04))
dbCreateRect(cvid list("POLY1" "drawing") list(91.02:14.72 92.02:15.14))
dbCreateRect(cvid list("METAL1" "drawing") list(91.15:14.72 91.90:15.14))
dbCreateRect(cvid list("CONT" "drawing") list(91.41:14.82 91.63:15.04))
dbCreateRect(cvid list("POLY1" "drawing") list(92.56:14.72 93.56:15.14))
dbCreateRect(cvid list("METAL1" "drawing") list(92.69:14.72 93.44:15.14))
dbCreateRect(cvid list("CONT" "drawing") list(92.95:14.82 93.17:15.04))
dbCreateRect(cvid list("DIFF" "drawing") list(80.55:3.33 81.01:3.79))
dbCreateRect(cvid list("METAL1" "drawing") list(80.55:3.33 81.01:3.79))
dbCreateRect(cvid list("CONT" "drawing") list(80.67:3.45 80.89:3.67))
dbCreateRect(cvid list("PIMP" "drawing") list(80.37:3.15 81.19:3.97))
dbCreateRect(cvid list("DIFF" "drawing") list(94.33:3.33 94.79:3.79))
dbCreateRect(cvid list("METAL1" "drawing") list(94.33:3.33 94.79:3.79))
dbCreateRect(cvid list("CONT" "drawing") list(94.45:3.45 94.67:3.67))
dbCreateRect(cvid list("PIMP" "drawing") list(94.15:3.15 94.97:3.97))
dbCreateRect(cvid list("DIFF" "drawing") list(80.55:15.42 81.01:15.88))
dbCreateRect(cvid list("METAL1" "drawing") list(80.55:15.42 81.01:15.88))
dbCreateRect(cvid list("CONT" "drawing") list(80.67:15.54 80.89:15.76))
dbCreateRect(cvid list("PIMP" "drawing") list(80.37:15.24 81.19:16.06))
dbCreateRect(cvid list("DIFF" "drawing") list(94.33:15.42 94.79:15.88))
dbCreateRect(cvid list("METAL1" "drawing") list(94.33:15.42 94.79:15.88))
dbCreateRect(cvid list("CONT" "drawing") list(94.45:15.54 94.67:15.76))
dbCreateRect(cvid list("PIMP" "drawing") list(94.15:15.24 94.97:16.06))
dbCreateRect(cvid list("DIFF" "drawing") list(80.55:3.79 81.01:15.42))
dbCreateRect(cvid list("METAL1" "drawing") list(80.55:3.79 81.01:15.42))
dbCreateRect(cvid list("CONT" "drawing") list(80.67:4.33 80.89:4.55))
dbCreateRect(cvid list("CONT" "drawing") list(80.67:4.80 80.89:5.02))
dbCreateRect(cvid list("CONT" "drawing") list(80.67:5.27 80.89:5.49))
dbCreateRect(cvid list("CONT" "drawing") list(80.67:5.74 80.89:5.96))
dbCreateRect(cvid list("CONT" "drawing") list(80.67:6.21 80.89:6.43))
dbCreateRect(cvid list("CONT" "drawing") list(80.67:6.68 80.89:6.90))
dbCreateRect(cvid list("CONT" "drawing") list(80.67:7.15 80.89:7.37))
dbCreateRect(cvid list("CONT" "drawing") list(80.67:7.62 80.89:7.84))
dbCreateRect(cvid list("CONT" "drawing") list(80.67:8.09 80.89:8.31))
dbCreateRect(cvid list("CONT" "drawing") list(80.67:8.56 80.89:8.78))
dbCreateRect(cvid list("CONT" "drawing") list(80.67:9.03 80.89:9.25))
dbCreateRect(cvid list("CONT" "drawing") list(80.67:9.50 80.89:9.72))
dbCreateRect(cvid list("CONT" "drawing") list(80.67:9.97 80.89:10.19))
dbCreateRect(cvid list("CONT" "drawing") list(80.67:10.44 80.89:10.66))
dbCreateRect(cvid list("CONT" "drawing") list(80.67:10.91 80.89:11.13))
dbCreateRect(cvid list("CONT" "drawing") list(80.67:11.38 80.89:11.60))
dbCreateRect(cvid list("CONT" "drawing") list(80.67:11.85 80.89:12.07))
dbCreateRect(cvid list("CONT" "drawing") list(80.67:12.32 80.89:12.54))
dbCreateRect(cvid list("CONT" "drawing") list(80.67:12.79 80.89:13.01))
dbCreateRect(cvid list("CONT" "drawing") list(80.67:13.26 80.89:13.48))
dbCreateRect(cvid list("CONT" "drawing") list(80.67:13.73 80.89:13.95))
dbCreateRect(cvid list("CONT" "drawing") list(80.67:14.20 80.89:14.42))
dbCreateRect(cvid list("CONT" "drawing") list(80.67:14.67 80.89:14.89))
dbCreateRect(cvid list("PIMP" "drawing") list(80.37:3.61 81.19:15.60))
dbCreateRect(cvid list("DIFF" "drawing") list(81.01:3.33 94.33:3.79))
dbCreateRect(cvid list("METAL1" "drawing") list(81.01:3.33 94.33:3.79))
dbCreateRect(cvid list("CONT" "drawing") list(81.45:3.45 81.67:3.67))
dbCreateRect(cvid list("CONT" "drawing") list(81.92:3.45 82.14:3.67))
dbCreateRect(cvid list("CONT" "drawing") list(82.39:3.45 82.61:3.67))
dbCreateRect(cvid list("CONT" "drawing") list(82.86:3.45 83.08:3.67))
dbCreateRect(cvid list("CONT" "drawing") list(83.33:3.45 83.55:3.67))
dbCreateRect(cvid list("CONT" "drawing") list(83.80:3.45 84.02:3.67))
dbCreateRect(cvid list("CONT" "drawing") list(84.27:3.45 84.49:3.67))
dbCreateRect(cvid list("CONT" "drawing") list(84.74:3.45 84.96:3.67))
dbCreateRect(cvid list("CONT" "drawing") list(85.21:3.45 85.43:3.67))
dbCreateRect(cvid list("CONT" "drawing") list(85.68:3.45 85.90:3.67))
dbCreateRect(cvid list("CONT" "drawing") list(86.15:3.45 86.37:3.67))
dbCreateRect(cvid list("CONT" "drawing") list(86.62:3.45 86.84:3.67))
dbCreateRect(cvid list("CONT" "drawing") list(87.09:3.45 87.31:3.67))
dbCreateRect(cvid list("CONT" "drawing") list(87.56:3.45 87.78:3.67))
dbCreateRect(cvid list("CONT" "drawing") list(88.03:3.45 88.25:3.67))
dbCreateRect(cvid list("CONT" "drawing") list(88.50:3.45 88.72:3.67))
dbCreateRect(cvid list("CONT" "drawing") list(88.97:3.45 89.19:3.67))
dbCreateRect(cvid list("CONT" "drawing") list(89.44:3.45 89.66:3.67))
dbCreateRect(cvid list("CONT" "drawing") list(89.91:3.45 90.13:3.67))
dbCreateRect(cvid list("CONT" "drawing") list(90.38:3.45 90.60:3.67))
dbCreateRect(cvid list("CONT" "drawing") list(90.85:3.45 91.07:3.67))
dbCreateRect(cvid list("CONT" "drawing") list(91.32:3.45 91.54:3.67))
dbCreateRect(cvid list("CONT" "drawing") list(91.79:3.45 92.01:3.67))
dbCreateRect(cvid list("CONT" "drawing") list(92.26:3.45 92.48:3.67))
dbCreateRect(cvid list("CONT" "drawing") list(92.73:3.45 92.95:3.67))
dbCreateRect(cvid list("CONT" "drawing") list(93.20:3.45 93.42:3.67))
dbCreateRect(cvid list("CONT" "drawing") list(93.67:3.45 93.89:3.67))
dbCreateRect(cvid list("PIMP" "drawing") list(80.83:3.15 94.52:3.97))
dbCreateRect(cvid list("DIFF" "drawing") list(94.33:3.79 94.79:15.42))
dbCreateRect(cvid list("METAL1" "drawing") list(94.33:3.79 94.79:15.42))
dbCreateRect(cvid list("CONT" "drawing") list(94.45:4.33 94.67:4.55))
dbCreateRect(cvid list("CONT" "drawing") list(94.45:4.80 94.67:5.02))
dbCreateRect(cvid list("CONT" "drawing") list(94.45:5.27 94.67:5.49))
dbCreateRect(cvid list("CONT" "drawing") list(94.45:5.74 94.67:5.96))
dbCreateRect(cvid list("CONT" "drawing") list(94.45:6.21 94.67:6.43))
dbCreateRect(cvid list("CONT" "drawing") list(94.45:6.68 94.67:6.90))
dbCreateRect(cvid list("CONT" "drawing") list(94.45:7.15 94.67:7.37))
dbCreateRect(cvid list("CONT" "drawing") list(94.45:7.62 94.67:7.84))
dbCreateRect(cvid list("CONT" "drawing") list(94.45:8.09 94.67:8.31))
dbCreateRect(cvid list("CONT" "drawing") list(94.45:8.56 94.67:8.78))
dbCreateRect(cvid list("CONT" "drawing") list(94.45:9.03 94.67:9.25))
dbCreateRect(cvid list("CONT" "drawing") list(94.45:9.50 94.67:9.72))
dbCreateRect(cvid list("CONT" "drawing") list(94.45:9.97 94.67:10.19))
dbCreateRect(cvid list("CONT" "drawing") list(94.45:10.44 94.67:10.66))
dbCreateRect(cvid list("CONT" "drawing") list(94.45:10.91 94.67:11.13))
dbCreateRect(cvid list("CONT" "drawing") list(94.45:11.38 94.67:11.60))
dbCreateRect(cvid list("CONT" "drawing") list(94.45:11.85 94.67:12.07))
dbCreateRect(cvid list("CONT" "drawing") list(94.45:12.32 94.67:12.54))
dbCreateRect(cvid list("CONT" "drawing") list(94.45:12.79 94.67:13.01))
dbCreateRect(cvid list("CONT" "drawing") list(94.45:13.26 94.67:13.48))
dbCreateRect(cvid list("CONT" "drawing") list(94.45:13.73 94.67:13.95))
dbCreateRect(cvid list("CONT" "drawing") list(94.45:14.20 94.67:14.42))
dbCreateRect(cvid list("CONT" "drawing") list(94.45:14.67 94.67:14.89))
dbCreateRect(cvid list("PIMP" "drawing") list(94.15:3.61 94.97:15.60))
dbCreateRect(cvid list("DIFF" "drawing") list(81.01:15.42 94.33:15.88))
dbCreateRect(cvid list("METAL1" "drawing") list(81.01:15.42 94.33:15.88))
dbCreateRect(cvid list("CONT" "drawing") list(81.45:15.54 81.67:15.76))
dbCreateRect(cvid list("CONT" "drawing") list(81.92:15.54 82.14:15.76))
dbCreateRect(cvid list("CONT" "drawing") list(82.39:15.54 82.61:15.76))
dbCreateRect(cvid list("CONT" "drawing") list(82.86:15.54 83.08:15.76))
dbCreateRect(cvid list("CONT" "drawing") list(83.33:15.54 83.55:15.76))
dbCreateRect(cvid list("CONT" "drawing") list(83.80:15.54 84.02:15.76))
dbCreateRect(cvid list("CONT" "drawing") list(84.27:15.54 84.49:15.76))
dbCreateRect(cvid list("CONT" "drawing") list(84.74:15.54 84.96:15.76))
dbCreateRect(cvid list("CONT" "drawing") list(85.21:15.54 85.43:15.76))
dbCreateRect(cvid list("CONT" "drawing") list(85.68:15.54 85.90:15.76))
dbCreateRect(cvid list("CONT" "drawing") list(86.15:15.54 86.37:15.76))
dbCreateRect(cvid list("CONT" "drawing") list(86.62:15.54 86.84:15.76))
dbCreateRect(cvid list("CONT" "drawing") list(87.09:15.54 87.31:15.76))
dbCreateRect(cvid list("CONT" "drawing") list(87.56:15.54 87.78:15.76))
dbCreateRect(cvid list("CONT" "drawing") list(88.03:15.54 88.25:15.76))
dbCreateRect(cvid list("CONT" "drawing") list(88.50:15.54 88.72:15.76))
dbCreateRect(cvid list("CONT" "drawing") list(88.97:15.54 89.19:15.76))
dbCreateRect(cvid list("CONT" "drawing") list(89.44:15.54 89.66:15.76))
dbCreateRect(cvid list("CONT" "drawing") list(89.91:15.54 90.13:15.76))
dbCreateRect(cvid list("CONT" "drawing") list(90.38:15.54 90.60:15.76))
dbCreateRect(cvid list("CONT" "drawing") list(90.85:15.54 91.07:15.76))
dbCreateRect(cvid list("CONT" "drawing") list(91.32:15.54 91.54:15.76))
dbCreateRect(cvid list("CONT" "drawing") list(91.79:15.54 92.01:15.76))
dbCreateRect(cvid list("CONT" "drawing") list(92.26:15.54 92.48:15.76))
dbCreateRect(cvid list("CONT" "drawing") list(92.73:15.54 92.95:15.76))
dbCreateRect(cvid list("CONT" "drawing") list(93.20:15.54 93.42:15.76))
dbCreateRect(cvid list("CONT" "drawing") list(93.67:15.54 93.89:15.76))
dbCreateRect(cvid list("PIMP" "drawing") list(80.83:15.24 94.52:16.06))
dbCreateParamInst(cvid masternmos "I51" list(57.665 4.500) "MY" 1 list(list("w" "string" "10.00u") list("l" "string" "1.00u") ))
dbCreateParamInst(cvid masternmos "M16.1" list(58.205 4.500) "R0" 1 list(list("w" "string" "10.00u") list("l" "string" "1.00u") ))
dbCreateParamInst(cvid masternmos "M16.2" list(60.745 4.500) "MY" 1 list(list("w" "string" "10.00u") list("l" "string" "1.00u") ))
dbCreateParamInst(cvid masternmos "M16.3" list(61.285 4.500) "R0" 1 list(list("w" "string" "10.00u") list("l" "string" "1.00u") ))
dbCreateParamInst(cvid masternmos "M16.4" list(63.825 4.500) "MY" 1 list(list("w" "string" "10.00u") list("l" "string" "1.00u") ))
dbCreateParamInst(cvid masternmos "M17.1" list(64.365 4.500) "R0" 1 list(list("w" "string" "10.00u") list("l" "string" "1.00u") ))
dbCreateParamInst(cvid masternmos "M17.2" list(66.905 4.500) "MY" 1 list(list("w" "string" "10.00u") list("l" "string" "1.00u") ))
dbCreateParamInst(cvid masternmos "M17.3" list(67.445 4.500) "R0" 1 list(list("w" "string" "10.00u") list("l" "string" "1.00u") ))
dbCreateParamInst(cvid masternmos "M17.4" list(69.985 4.500) "MY" 1 list(list("w" "string" "10.00u") list("l" "string" "1.00u") ))
dbCreateParamInst(cvid masternmos "M17.5" list(70.525 4.500) "R0" 1 list(list("w" "string" "10.00u") list("l" "string" "1.00u") ))
dbCreateParamInst(cvid masternmos "M17.6" list(73.065 4.500) "MY" 1 list(list("w" "string" "10.00u") list("l" "string" "1.00u") ))
dbCreateParamInst(cvid masternmos "M17.7" list(73.605 4.500) "R0" 1 list(list("w" "string" "10.00u") list("l" "string" "1.00u") ))
dbCreateParamInst(cvid masternmos "M17.8" list(76.145 4.500) "MY" 1 list(list("w" "string" "10.00u") list("l" "string" "1.00u") ))
dbCreateParamInst(cvid masternmos "I53" list(76.685 4.500) "R0" 1 list(list("w" "string" "10.00u") list("l" "string" "1.00u") ))
dbCreateRect(cvid list("METAL1" "drawing") list(56.19:4.50 56.59:14.50))
dbCreateRect(cvid list("METAL1" "drawing") list(57.73:4.50 58.13:14.50))
dbCreateRect(cvid list("METAL1" "drawing") list(59.27:4.50 59.67:14.50))
dbCreateRect(cvid list("METAL1" "drawing") list(60.81:4.50 61.21:14.50))
dbCreateRect(cvid list("METAL1" "drawing") list(62.35:4.50 62.75:14.50))
dbCreateRect(cvid list("METAL1" "drawing") list(63.89:4.50 64.29:14.50))
dbCreateRect(cvid list("METAL1" "drawing") list(65.43:4.50 65.83:14.50))
dbCreateRect(cvid list("METAL1" "drawing") list(66.97:4.50 67.37:14.50))
dbCreateRect(cvid list("METAL1" "drawing") list(68.51:4.50 68.91:14.50))
dbCreateRect(cvid list("METAL1" "drawing") list(70.05:4.50 70.45:14.50))
dbCreateRect(cvid list("METAL1" "drawing") list(71.59:4.50 71.99:14.50))
dbCreateRect(cvid list("METAL1" "drawing") list(73.13:4.50 73.53:14.50))
dbCreateRect(cvid list("METAL1" "drawing") list(74.67:4.50 75.07:14.50))
dbCreateRect(cvid list("METAL1" "drawing") list(76.21:4.50 76.61:14.50))
dbCreateRect(cvid list("METAL1" "drawing") list(77.75:4.50 78.16:14.50))
dbCreateRect(cvid list("POLY1" "drawing") list(56.66:14.72 57.66:15.14))
dbCreateRect(cvid list("METAL1" "drawing") list(56.79:14.72 57.54:15.14))
dbCreateRect(cvid list("CONT" "drawing") list(57.05:14.82 57.27:15.04))
dbCreateRect(cvid list("POLY1" "drawing") list(58.20:14.72 59.20:15.14))
dbCreateRect(cvid list("METAL1" "drawing") list(58.33:14.72 59.08:15.14))
dbCreateRect(cvid list("CONT" "drawing") list(58.59:14.82 58.81:15.04))
dbCreateRect(cvid list("POLY1" "drawing") list(59.74:14.72 60.74:15.14))
dbCreateRect(cvid list("METAL1" "drawing") list(59.87:14.72 60.62:15.14))
dbCreateRect(cvid list("CONT" "drawing") list(60.13:14.82 60.35:15.04))
dbCreateRect(cvid list("POLY1" "drawing") list(61.28:14.72 62.28:15.14))
dbCreateRect(cvid list("METAL1" "drawing") list(61.41:14.72 62.16:15.14))
dbCreateRect(cvid list("CONT" "drawing") list(61.67:14.82 61.89:15.04))
dbCreateRect(cvid list("POLY1" "drawing") list(62.82:14.72 63.82:15.14))
dbCreateRect(cvid list("METAL1" "drawing") list(62.95:14.72 63.70:15.14))
dbCreateRect(cvid list("CONT" "drawing") list(63.21:14.82 63.43:15.04))
dbCreateRect(cvid list("POLY1" "drawing") list(64.36:14.72 65.36:15.14))
dbCreateRect(cvid list("METAL1" "drawing") list(64.49:14.72 65.24:15.14))
dbCreateRect(cvid list("CONT" "drawing") list(64.75:14.82 64.97:15.04))
dbCreateRect(cvid list("POLY1" "drawing") list(65.90:14.72 66.90:15.14))
dbCreateRect(cvid list("METAL1" "drawing") list(66.03:14.72 66.78:15.14))
dbCreateRect(cvid list("CONT" "drawing") list(66.29:14.82 66.51:15.04))
dbCreateRect(cvid list("POLY1" "drawing") list(67.44:14.72 68.44:15.14))
dbCreateRect(cvid list("METAL1" "drawing") list(67.57:14.72 68.32:15.14))
dbCreateRect(cvid list("CONT" "drawing") list(67.83:14.82 68.05:15.04))
dbCreateRect(cvid list("POLY1" "drawing") list(68.98:14.72 69.98:15.14))
dbCreateRect(cvid list("METAL1" "drawing") list(69.11:14.72 69.86:15.14))
dbCreateRect(cvid list("CONT" "drawing") list(69.37:14.82 69.59:15.04))
dbCreateRect(cvid list("POLY1" "drawing") list(70.52:14.72 71.52:15.14))
dbCreateRect(cvid list("METAL1" "drawing") list(70.65:14.72 71.40:15.14))
dbCreateRect(cvid list("CONT" "drawing") list(70.91:14.82 71.13:15.04))
dbCreateRect(cvid list("POLY1" "drawing") list(72.06:14.72 73.06:15.14))
dbCreateRect(cvid list("METAL1" "drawing") list(72.19:14.72 72.94:15.14))
dbCreateRect(cvid list("CONT" "drawing") list(72.45:14.82 72.67:15.04))
dbCreateRect(cvid list("POLY1" "drawing") list(73.60:14.72 74.60:15.14))
dbCreateRect(cvid list("METAL1" "drawing") list(73.73:14.72 74.48:15.14))
dbCreateRect(cvid list("CONT" "drawing") list(73.99:14.82 74.21:15.04))
dbCreateRect(cvid list("POLY1" "drawing") list(75.14:14.72 76.14:15.14))
dbCreateRect(cvid list("METAL1" "drawing") list(75.27:14.72 76.02:15.14))
dbCreateRect(cvid list("CONT" "drawing") list(75.53:14.82 75.75:15.04))
dbCreateRect(cvid list("POLY1" "drawing") list(76.69:14.72 77.69:15.14))
dbCreateRect(cvid list("METAL1" "drawing") list(76.81:14.72 77.56:15.14))
dbCreateRect(cvid list("CONT" "drawing") list(77.08:14.82 77.30:15.04))
dbCreateRect(cvid list("DIFF" "drawing") list(55.01:3.33 55.47:3.79))
dbCreateRect(cvid list("METAL1" "drawing") list(55.01:3.33 55.47:3.79))
dbCreateRect(cvid list("CONT" "drawing") list(55.13:3.45 55.35:3.67))
dbCreateRect(cvid list("PIMP" "drawing") list(54.83:3.15 55.65:3.97))
dbCreateRect(cvid list("DIFF" "drawing") list(78.88:3.33 79.33:3.79))
dbCreateRect(cvid list("METAL1" "drawing") list(78.88:3.33 79.33:3.79))
dbCreateRect(cvid list("CONT" "drawing") list(78.99:3.45 79.21:3.67))
dbCreateRect(cvid list("PIMP" "drawing") list(78.69:3.15 79.52:3.97))
dbCreateRect(cvid list("DIFF" "drawing") list(55.01:15.42 55.47:15.88))
dbCreateRect(cvid list("METAL1" "drawing") list(55.01:15.42 55.47:15.88))
dbCreateRect(cvid list("CONT" "drawing") list(55.13:15.54 55.35:15.76))
dbCreateRect(cvid list("PIMP" "drawing") list(54.83:15.24 55.65:16.06))
dbCreateRect(cvid list("DIFF" "drawing") list(78.88:15.42 79.33:15.88))
dbCreateRect(cvid list("METAL1" "drawing") list(78.88:15.42 79.33:15.88))
dbCreateRect(cvid list("CONT" "drawing") list(78.99:15.54 79.21:15.76))
dbCreateRect(cvid list("PIMP" "drawing") list(78.69:15.24 79.52:16.06))
dbCreateRect(cvid list("DIFF" "drawing") list(55.01:3.79 55.47:15.42))
dbCreateRect(cvid list("METAL1" "drawing") list(55.01:3.79 55.47:15.42))
dbCreateRect(cvid list("CONT" "drawing") list(55.13:4.33 55.35:4.55))
dbCreateRect(cvid list("CONT" "drawing") list(55.13:4.80 55.35:5.02))
dbCreateRect(cvid list("CONT" "drawing") list(55.13:5.27 55.35:5.49))
dbCreateRect(cvid list("CONT" "drawing") list(55.13:5.74 55.35:5.96))
dbCreateRect(cvid list("CONT" "drawing") list(55.13:6.21 55.35:6.43))
dbCreateRect(cvid list("CONT" "drawing") list(55.13:6.68 55.35:6.90))
dbCreateRect(cvid list("CONT" "drawing") list(55.13:7.15 55.35:7.37))
dbCreateRect(cvid list("CONT" "drawing") list(55.13:7.62 55.35:7.84))
dbCreateRect(cvid list("CONT" "drawing") list(55.13:8.09 55.35:8.31))
dbCreateRect(cvid list("CONT" "drawing") list(55.13:8.56 55.35:8.78))
dbCreateRect(cvid list("CONT" "drawing") list(55.13:9.03 55.35:9.25))
dbCreateRect(cvid list("CONT" "drawing") list(55.13:9.50 55.35:9.72))
dbCreateRect(cvid list("CONT" "drawing") list(55.13:9.97 55.35:10.19))
dbCreateRect(cvid list("CONT" "drawing") list(55.13:10.44 55.35:10.66))
dbCreateRect(cvid list("CONT" "drawing") list(55.13:10.91 55.35:11.13))
dbCreateRect(cvid list("CONT" "drawing") list(55.13:11.38 55.35:11.60))
dbCreateRect(cvid list("CONT" "drawing") list(55.13:11.85 55.35:12.07))
dbCreateRect(cvid list("CONT" "drawing") list(55.13:12.32 55.35:12.54))
dbCreateRect(cvid list("CONT" "drawing") list(55.13:12.79 55.35:13.01))
dbCreateRect(cvid list("CONT" "drawing") list(55.13:13.26 55.35:13.48))
dbCreateRect(cvid list("CONT" "drawing") list(55.13:13.73 55.35:13.95))
dbCreateRect(cvid list("CONT" "drawing") list(55.13:14.20 55.35:14.42))
dbCreateRect(cvid list("CONT" "drawing") list(55.13:14.67 55.35:14.89))
dbCreateRect(cvid list("PIMP" "drawing") list(54.83:3.61 55.65:15.60))
dbCreateRect(cvid list("DIFF" "drawing") list(55.47:3.33 78.88:3.79))
dbCreateRect(cvid list("METAL1" "drawing") list(55.47:3.33 78.88:3.79))
dbCreateRect(cvid list("CONT" "drawing") list(55.78:3.45 56.00:3.67))
dbCreateRect(cvid list("CONT" "drawing") list(56.25:3.45 56.47:3.67))
dbCreateRect(cvid list("CONT" "drawing") list(56.72:3.45 56.94:3.67))
dbCreateRect(cvid list("CONT" "drawing") list(57.19:3.45 57.41:3.67))
dbCreateRect(cvid list("CONT" "drawing") list(57.66:3.45 57.88:3.67))
dbCreateRect(cvid list("CONT" "drawing") list(58.13:3.45 58.35:3.67))
dbCreateRect(cvid list("CONT" "drawing") list(58.60:3.45 58.82:3.67))
dbCreateRect(cvid list("CONT" "drawing") list(59.07:3.45 59.29:3.67))
dbCreateRect(cvid list("CONT" "drawing") list(59.54:3.45 59.76:3.67))
dbCreateRect(cvid list("CONT" "drawing") list(60.01:3.45 60.23:3.67))
dbCreateRect(cvid list("CONT" "drawing") list(60.48:3.45 60.70:3.67))
dbCreateRect(cvid list("CONT" "drawing") list(60.95:3.45 61.17:3.67))
dbCreateRect(cvid list("CONT" "drawing") list(61.42:3.45 61.64:3.67))
dbCreateRect(cvid list("CONT" "drawing") list(61.89:3.45 62.11:3.67))
dbCreateRect(cvid list("CONT" "drawing") list(62.36:3.45 62.58:3.67))
dbCreateRect(cvid list("CONT" "drawing") list(62.83:3.45 63.05:3.67))
dbCreateRect(cvid list("CONT" "drawing") list(63.30:3.45 63.52:3.67))
dbCreateRect(cvid list("CONT" "drawing") list(63.77:3.45 63.99:3.67))
dbCreateRect(cvid list("CONT" "drawing") list(64.24:3.45 64.46:3.67))
dbCreateRect(cvid list("CONT" "drawing") list(64.71:3.45 64.93:3.67))
dbCreateRect(cvid list("CONT" "drawing") list(65.18:3.45 65.40:3.67))
dbCreateRect(cvid list("CONT" "drawing") list(65.65:3.45 65.87:3.67))
dbCreateRect(cvid list("CONT" "drawing") list(66.12:3.45 66.34:3.67))
dbCreateRect(cvid list("CONT" "drawing") list(66.59:3.45 66.81:3.67))
dbCreateRect(cvid list("CONT" "drawing") list(67.06:3.45 67.28:3.67))
dbCreateRect(cvid list("CONT" "drawing") list(67.53:3.45 67.75:3.67))
dbCreateRect(cvid list("CONT" "drawing") list(68.00:3.45 68.22:3.67))
dbCreateRect(cvid list("CONT" "drawing") list(68.47:3.45 68.69:3.67))
dbCreateRect(cvid list("CONT" "drawing") list(68.94:3.45 69.16:3.67))
dbCreateRect(cvid list("CONT" "drawing") list(69.41:3.45 69.63:3.67))
dbCreateRect(cvid list("CONT" "drawing") list(69.88:3.45 70.10:3.67))
dbCreateRect(cvid list("CONT" "drawing") list(70.35:3.45 70.57:3.67))
dbCreateRect(cvid list("CONT" "drawing") list(70.82:3.45 71.04:3.67))
dbCreateRect(cvid list("CONT" "drawing") list(71.29:3.45 71.51:3.67))
dbCreateRect(cvid list("CONT" "drawing") list(71.76:3.45 71.98:3.67))
dbCreateRect(cvid list("CONT" "drawing") list(72.23:3.45 72.45:3.67))
dbCreateRect(cvid list("CONT" "drawing") list(72.70:3.45 72.92:3.67))
dbCreateRect(cvid list("CONT" "drawing") list(73.17:3.45 73.39:3.67))
dbCreateRect(cvid list("CONT" "drawing") list(73.64:3.45 73.86:3.67))
dbCreateRect(cvid list("CONT" "drawing") list(74.11:3.45 74.33:3.67))
dbCreateRect(cvid list("CONT" "drawing") list(74.58:3.45 74.80:3.67))
dbCreateRect(cvid list("CONT" "drawing") list(75.05:3.45 75.27:3.67))
dbCreateRect(cvid list("CONT" "drawing") list(75.52:3.45 75.74:3.67))
dbCreateRect(cvid list("CONT" "drawing") list(75.99:3.45 76.21:3.67))
dbCreateRect(cvid list("CONT" "drawing") list(76.46:3.45 76.68:3.67))
dbCreateRect(cvid list("CONT" "drawing") list(76.93:3.45 77.15:3.67))
dbCreateRect(cvid list("CONT" "drawing") list(77.40:3.45 77.62:3.67))
dbCreateRect(cvid list("CONT" "drawing") list(77.87:3.45 78.09:3.67))
dbCreateRect(cvid list("CONT" "drawing") list(78.34:3.45 78.56:3.67))
dbCreateRect(cvid list("PIMP" "drawing") list(55.29:3.15 79.06:3.97))
dbCreateRect(cvid list("DIFF" "drawing") list(78.88:3.79 79.33:15.42))
dbCreateRect(cvid list("METAL1" "drawing") list(78.88:3.79 79.33:15.42))
dbCreateRect(cvid list("CONT" "drawing") list(78.99:4.33 79.21:4.55))
dbCreateRect(cvid list("CONT" "drawing") list(78.99:4.80 79.21:5.02))
dbCreateRect(cvid list("CONT" "drawing") list(78.99:5.27 79.21:5.49))
dbCreateRect(cvid list("CONT" "drawing") list(78.99:5.74 79.21:5.96))
dbCreateRect(cvid list("CONT" "drawing") list(78.99:6.21 79.21:6.43))
dbCreateRect(cvid list("CONT" "drawing") list(78.99:6.68 79.21:6.90))
dbCreateRect(cvid list("CONT" "drawing") list(78.99:7.15 79.21:7.37))
dbCreateRect(cvid list("CONT" "drawing") list(78.99:7.62 79.21:7.84))
dbCreateRect(cvid list("CONT" "drawing") list(78.99:8.09 79.21:8.31))
dbCreateRect(cvid list("CONT" "drawing") list(78.99:8.56 79.21:8.78))
dbCreateRect(cvid list("CONT" "drawing") list(78.99:9.03 79.21:9.25))
dbCreateRect(cvid list("CONT" "drawing") list(78.99:9.50 79.21:9.72))
dbCreateRect(cvid list("CONT" "drawing") list(78.99:9.97 79.21:10.19))
dbCreateRect(cvid list("CONT" "drawing") list(78.99:10.44 79.21:10.66))
dbCreateRect(cvid list("CONT" "drawing") list(78.99:10.91 79.21:11.13))
dbCreateRect(cvid list("CONT" "drawing") list(78.99:11.38 79.21:11.60))
dbCreateRect(cvid list("CONT" "drawing") list(78.99:11.85 79.21:12.07))
dbCreateRect(cvid list("CONT" "drawing") list(78.99:12.32 79.21:12.54))
dbCreateRect(cvid list("CONT" "drawing") list(78.99:12.79 79.21:13.01))
dbCreateRect(cvid list("CONT" "drawing") list(78.99:13.26 79.21:13.48))
dbCreateRect(cvid list("CONT" "drawing") list(78.99:13.73 79.21:13.95))
dbCreateRect(cvid list("CONT" "drawing") list(78.99:14.20 79.21:14.42))
dbCreateRect(cvid list("CONT" "drawing") list(78.99:14.67 79.21:14.89))
dbCreateRect(cvid list("PIMP" "drawing") list(78.69:3.61 79.52:15.60))
dbCreateRect(cvid list("DIFF" "drawing") list(55.47:15.42 78.88:15.88))
dbCreateRect(cvid list("METAL1" "drawing") list(55.47:15.42 78.88:15.88))
dbCreateRect(cvid list("CONT" "drawing") list(55.78:15.54 56.00:15.76))
dbCreateRect(cvid list("CONT" "drawing") list(56.25:15.54 56.47:15.76))
dbCreateRect(cvid list("CONT" "drawing") list(56.72:15.54 56.94:15.76))
dbCreateRect(cvid list("CONT" "drawing") list(57.19:15.54 57.41:15.76))
dbCreateRect(cvid list("CONT" "drawing") list(57.66:15.54 57.88:15.76))
dbCreateRect(cvid list("CONT" "drawing") list(58.13:15.54 58.35:15.76))
dbCreateRect(cvid list("CONT" "drawing") list(58.60:15.54 58.82:15.76))
dbCreateRect(cvid list("CONT" "drawing") list(59.07:15.54 59.29:15.76))
dbCreateRect(cvid list("CONT" "drawing") list(59.54:15.54 59.76:15.76))
dbCreateRect(cvid list("CONT" "drawing") list(60.01:15.54 60.23:15.76))
dbCreateRect(cvid list("CONT" "drawing") list(60.48:15.54 60.70:15.76))
dbCreateRect(cvid list("CONT" "drawing") list(60.95:15.54 61.17:15.76))
dbCreateRect(cvid list("CONT" "drawing") list(61.42:15.54 61.64:15.76))
dbCreateRect(cvid list("CONT" "drawing") list(61.89:15.54 62.11:15.76))
dbCreateRect(cvid list("CONT" "drawing") list(62.36:15.54 62.58:15.76))
dbCreateRect(cvid list("CONT" "drawing") list(62.83:15.54 63.05:15.76))
dbCreateRect(cvid list("CONT" "drawing") list(63.30:15.54 63.52:15.76))
dbCreateRect(cvid list("CONT" "drawing") list(63.77:15.54 63.99:15.76))
dbCreateRect(cvid list("CONT" "drawing") list(64.24:15.54 64.46:15.76))
dbCreateRect(cvid list("CONT" "drawing") list(64.71:15.54 64.93:15.76))
dbCreateRect(cvid list("CONT" "drawing") list(65.18:15.54 65.40:15.76))
dbCreateRect(cvid list("CONT" "drawing") list(65.65:15.54 65.87:15.76))
dbCreateRect(cvid list("CONT" "drawing") list(66.12:15.54 66.34:15.76))
dbCreateRect(cvid list("CONT" "drawing") list(66.59:15.54 66.81:15.76))
dbCreateRect(cvid list("CONT" "drawing") list(67.06:15.54 67.28:15.76))
dbCreateRect(cvid list("CONT" "drawing") list(67.53:15.54 67.75:15.76))
dbCreateRect(cvid list("CONT" "drawing") list(68.00:15.54 68.22:15.76))
dbCreateRect(cvid list("CONT" "drawing") list(68.47:15.54 68.69:15.76))
dbCreateRect(cvid list("CONT" "drawing") list(68.94:15.54 69.16:15.76))
dbCreateRect(cvid list("CONT" "drawing") list(69.41:15.54 69.63:15.76))
dbCreateRect(cvid list("CONT" "drawing") list(69.88:15.54 70.10:15.76))
dbCreateRect(cvid list("CONT" "drawing") list(70.35:15.54 70.57:15.76))
dbCreateRect(cvid list("CONT" "drawing") list(70.82:15.54 71.04:15.76))
dbCreateRect(cvid list("CONT" "drawing") list(71.29:15.54 71.51:15.76))
dbCreateRect(cvid list("CONT" "drawing") list(71.76:15.54 71.98:15.76))
dbCreateRect(cvid list("CONT" "drawing") list(72.23:15.54 72.45:15.76))
dbCreateRect(cvid list("CONT" "drawing") list(72.70:15.54 72.92:15.76))
dbCreateRect(cvid list("CONT" "drawing") list(73.17:15.54 73.39:15.76))
dbCreateRect(cvid list("CONT" "drawing") list(73.64:15.54 73.86:15.76))
dbCreateRect(cvid list("CONT" "drawing") list(74.11:15.54 74.33:15.76))
dbCreateRect(cvid list("CONT" "drawing") list(74.58:15.54 74.80:15.76))
dbCreateRect(cvid list("CONT" "drawing") list(75.05:15.54 75.27:15.76))
dbCreateRect(cvid list("CONT" "drawing") list(75.52:15.54 75.74:15.76))
dbCreateRect(cvid list("CONT" "drawing") list(75.99:15.54 76.21:15.76))
dbCreateRect(cvid list("CONT" "drawing") list(76.46:15.54 76.68:15.76))
dbCreateRect(cvid list("CONT" "drawing") list(76.93:15.54 77.15:15.76))
dbCreateRect(cvid list("CONT" "drawing") list(77.40:15.54 77.62:15.76))
dbCreateRect(cvid list("CONT" "drawing") list(77.87:15.54 78.09:15.76))
dbCreateRect(cvid list("CONT" "drawing") list(78.34:15.54 78.56:15.76))
dbCreateRect(cvid list("PIMP" "drawing") list(55.29:15.24 79.06:16.06))
dbCreateParamInst(cvid masternmos "I47" list(46.145 4.430) "R0" 1 list(list("w" "string" "14.40u") list("l" "string" "1.20u") ))
dbCreateParamInst(cvid masternmos "M5" list(47.885 4.430) "R0" 1 list(list("w" "string" "14.40u") list("l" "string" "1.20u") ))
dbCreateParamInst(cvid masternmos "M6" list(49.625 4.430) "R0" 1 list(list("w" "string" "14.40u") list("l" "string" "1.20u") ))
dbCreateParamInst(cvid masternmos "I46" list(51.365 4.430) "R0" 1 list(list("w" "string" "14.40u") list("l" "string" "1.20u") ))
dbCreateRect(cvid list("METAL1" "drawing") list(45.68:4.43 46.08:18.83))
dbCreateRect(cvid list("METAL1" "drawing") list(47.42:4.43 47.82:18.83))
dbCreateRect(cvid list("METAL1" "drawing") list(49.16:4.43 49.56:18.83))
dbCreateRect(cvid list("METAL1" "drawing") list(50.90:4.43 51.30:18.83))
dbCreateRect(cvid list("METAL1" "drawing") list(52.63:4.43 53.04:18.83))
dbCreateRect(cvid list("POLY1" "drawing") list(46.15:19.05 47.35:19.47))
dbCreateRect(cvid list("METAL1" "drawing") list(46.27:19.05 47.22:19.47))
dbCreateRect(cvid list("CONT" "drawing") list(46.64:19.15 46.86:19.37))
dbCreateRect(cvid list("POLY1" "drawing") list(47.89:19.05 49.09:19.47))
dbCreateRect(cvid list("METAL1" "drawing") list(48.01:19.05 48.96:19.47))
dbCreateRect(cvid list("CONT" "drawing") list(48.38:19.15 48.60:19.37))
dbCreateRect(cvid list("POLY1" "drawing") list(49.63:19.05 50.83:19.47))
dbCreateRect(cvid list("METAL1" "drawing") list(49.75:19.05 50.70:19.47))
dbCreateRect(cvid list("CONT" "drawing") list(50.12:19.15 50.34:19.37))
dbCreateRect(cvid list("POLY1" "drawing") list(51.37:19.05 52.57:19.47))
dbCreateRect(cvid list("METAL1" "drawing") list(51.49:19.05 52.44:19.47))
dbCreateRect(cvid list("CONT" "drawing") list(51.86:19.15 52.08:19.37))
dbCreateRect(cvid list("DIFF" "drawing") list(44.50:3.26 44.96:3.72))
dbCreateRect(cvid list("METAL1" "drawing") list(44.50:3.26 44.96:3.72))
dbCreateRect(cvid list("CONT" "drawing") list(44.62:3.38 44.84:3.60))
dbCreateRect(cvid list("PIMP" "drawing") list(44.32:3.08 45.14:3.90))
dbCreateRect(cvid list("DIFF" "drawing") list(53.76:3.26 54.22:3.72))
dbCreateRect(cvid list("METAL1" "drawing") list(53.76:3.26 54.22:3.72))
dbCreateRect(cvid list("CONT" "drawing") list(53.88:3.38 54.09:3.60))
dbCreateRect(cvid list("PIMP" "drawing") list(53.58:3.08 54.40:3.90))
dbCreateRect(cvid list("DIFF" "drawing") list(44.50:19.75 44.96:20.21))
dbCreateRect(cvid list("METAL1" "drawing") list(44.50:19.75 44.96:20.21))
dbCreateRect(cvid list("CONT" "drawing") list(44.62:19.87 44.84:20.09))
dbCreateRect(cvid list("PIMP" "drawing") list(44.32:19.57 45.14:20.39))
dbCreateRect(cvid list("DIFF" "drawing") list(53.76:19.75 54.22:20.21))
dbCreateRect(cvid list("METAL1" "drawing") list(53.76:19.75 54.22:20.21))
dbCreateRect(cvid list("CONT" "drawing") list(53.88:19.87 54.09:20.09))
dbCreateRect(cvid list("PIMP" "drawing") list(53.58:19.57 54.40:20.39))
dbCreateRect(cvid list("DIFF" "drawing") list(44.50:3.72 44.96:19.75))
dbCreateRect(cvid list("METAL1" "drawing") list(44.50:3.72 44.96:19.75))
dbCreateRect(cvid list("CONT" "drawing") list(44.62:4.11 44.84:4.33))
dbCreateRect(cvid list("CONT" "drawing") list(44.62:4.58 44.84:4.80))
dbCreateRect(cvid list("CONT" "drawing") list(44.62:5.05 44.84:5.27))
dbCreateRect(cvid list("CONT" "drawing") list(44.62:5.52 44.84:5.74))
dbCreateRect(cvid list("CONT" "drawing") list(44.62:5.99 44.84:6.21))
dbCreateRect(cvid list("CONT" "drawing") list(44.62:6.46 44.84:6.68))
dbCreateRect(cvid list("CONT" "drawing") list(44.62:6.93 44.84:7.15))
dbCreateRect(cvid list("CONT" "drawing") list(44.62:7.40 44.84:7.62))
dbCreateRect(cvid list("CONT" "drawing") list(44.62:7.87 44.84:8.09))
dbCreateRect(cvid list("CONT" "drawing") list(44.62:8.34 44.84:8.56))
dbCreateRect(cvid list("CONT" "drawing") list(44.62:8.81 44.84:9.03))
dbCreateRect(cvid list("CONT" "drawing") list(44.62:9.28 44.84:9.50))
dbCreateRect(cvid list("CONT" "drawing") list(44.62:9.75 44.84:9.97))
dbCreateRect(cvid list("CONT" "drawing") list(44.62:10.22 44.84:10.44))
dbCreateRect(cvid list("CONT" "drawing") list(44.62:10.69 44.84:10.91))
dbCreateRect(cvid list("CONT" "drawing") list(44.62:11.16 44.84:11.38))
dbCreateRect(cvid list("CONT" "drawing") list(44.62:11.63 44.84:11.85))
dbCreateRect(cvid list("CONT" "drawing") list(44.62:12.10 44.84:12.32))
dbCreateRect(cvid list("CONT" "drawing") list(44.62:12.57 44.84:12.79))
dbCreateRect(cvid list("CONT" "drawing") list(44.62:13.04 44.84:13.26))
dbCreateRect(cvid list("CONT" "drawing") list(44.62:13.51 44.84:13.73))
dbCreateRect(cvid list("CONT" "drawing") list(44.62:13.98 44.84:14.20))
dbCreateRect(cvid list("CONT" "drawing") list(44.62:14.45 44.84:14.67))
dbCreateRect(cvid list("CONT" "drawing") list(44.62:14.92 44.84:15.14))
dbCreateRect(cvid list("CONT" "drawing") list(44.62:15.39 44.84:15.61))
dbCreateRect(cvid list("CONT" "drawing") list(44.62:15.86 44.84:16.07))
dbCreateRect(cvid list("CONT" "drawing") list(44.62:16.33 44.84:16.55))
dbCreateRect(cvid list("CONT" "drawing") list(44.62:16.80 44.84:17.02))
dbCreateRect(cvid list("CONT" "drawing") list(44.62:17.27 44.84:17.48))
dbCreateRect(cvid list("CONT" "drawing") list(44.62:17.73 44.84:17.95))
dbCreateRect(cvid list("CONT" "drawing") list(44.62:18.21 44.84:18.43))
dbCreateRect(cvid list("CONT" "drawing") list(44.62:18.68 44.84:18.89))
dbCreateRect(cvid list("CONT" "drawing") list(44.62:19.15 44.84:19.37))
dbCreateRect(cvid list("PIMP" "drawing") list(44.32:3.54 45.14:19.93))
dbCreateRect(cvid list("DIFF" "drawing") list(44.96:3.26 53.76:3.72))
dbCreateRect(cvid list("METAL1" "drawing") list(44.96:3.26 53.76:3.72))
dbCreateRect(cvid list("CONT" "drawing") list(45.49:3.38 45.71:3.60))
dbCreateRect(cvid list("CONT" "drawing") list(45.96:3.38 46.18:3.60))
dbCreateRect(cvid list("CONT" "drawing") list(46.43:3.38 46.65:3.60))
dbCreateRect(cvid list("CONT" "drawing") list(46.90:3.38 47.12:3.60))
dbCreateRect(cvid list("CONT" "drawing") list(47.37:3.38 47.59:3.60))
dbCreateRect(cvid list("CONT" "drawing") list(47.84:3.38 48.06:3.60))
dbCreateRect(cvid list("CONT" "drawing") list(48.31:3.38 48.53:3.60))
dbCreateRect(cvid list("CONT" "drawing") list(48.78:3.38 49.00:3.60))
dbCreateRect(cvid list("CONT" "drawing") list(49.25:3.38 49.47:3.60))
dbCreateRect(cvid list("CONT" "drawing") list(49.72:3.38 49.94:3.60))
dbCreateRect(cvid list("CONT" "drawing") list(50.19:3.38 50.41:3.60))
dbCreateRect(cvid list("CONT" "drawing") list(50.66:3.38 50.88:3.60))
dbCreateRect(cvid list("CONT" "drawing") list(51.13:3.38 51.35:3.60))
dbCreateRect(cvid list("CONT" "drawing") list(51.60:3.38 51.82:3.60))
dbCreateRect(cvid list("CONT" "drawing") list(52.07:3.38 52.29:3.60))
dbCreateRect(cvid list("CONT" "drawing") list(52.54:3.38 52.76:3.60))
dbCreateRect(cvid list("CONT" "drawing") list(53.01:3.38 53.23:3.60))
dbCreateRect(cvid list("PIMP" "drawing") list(44.78:3.08 53.94:3.90))
dbCreateRect(cvid list("DIFF" "drawing") list(53.76:3.72 54.22:19.75))
dbCreateRect(cvid list("METAL1" "drawing") list(53.76:3.72 54.22:19.75))
dbCreateRect(cvid list("CONT" "drawing") list(53.88:4.11 54.09:4.33))
dbCreateRect(cvid list("CONT" "drawing") list(53.88:4.58 54.09:4.80))
dbCreateRect(cvid list("CONT" "drawing") list(53.88:5.05 54.09:5.27))
dbCreateRect(cvid list("CONT" "drawing") list(53.88:5.52 54.09:5.74))
dbCreateRect(cvid list("CONT" "drawing") list(53.88:5.99 54.09:6.21))
dbCreateRect(cvid list("CONT" "drawing") list(53.88:6.46 54.09:6.68))
dbCreateRect(cvid list("CONT" "drawing") list(53.88:6.93 54.09:7.15))
dbCreateRect(cvid list("CONT" "drawing") list(53.88:7.40 54.09:7.62))
dbCreateRect(cvid list("CONT" "drawing") list(53.88:7.87 54.09:8.09))
dbCreateRect(cvid list("CONT" "drawing") list(53.88:8.34 54.09:8.56))
dbCreateRect(cvid list("CONT" "drawing") list(53.88:8.81 54.09:9.03))
dbCreateRect(cvid list("CONT" "drawing") list(53.88:9.28 54.09:9.50))
dbCreateRect(cvid list("CONT" "drawing") list(53.88:9.75 54.09:9.97))
dbCreateRect(cvid list("CONT" "drawing") list(53.88:10.22 54.09:10.44))
dbCreateRect(cvid list("CONT" "drawing") list(53.88:10.69 54.09:10.91))
dbCreateRect(cvid list("CONT" "drawing") list(53.88:11.16 54.09:11.38))
dbCreateRect(cvid list("CONT" "drawing") list(53.88:11.63 54.09:11.85))
dbCreateRect(cvid list("CONT" "drawing") list(53.88:12.10 54.09:12.32))
dbCreateRect(cvid list("CONT" "drawing") list(53.88:12.57 54.09:12.79))
dbCreateRect(cvid list("CONT" "drawing") list(53.88:13.04 54.09:13.26))
dbCreateRect(cvid list("CONT" "drawing") list(53.88:13.51 54.09:13.73))
dbCreateRect(cvid list("CONT" "drawing") list(53.88:13.98 54.09:14.20))
dbCreateRect(cvid list("CONT" "drawing") list(53.88:14.45 54.09:14.67))
dbCreateRect(cvid list("CONT" "drawing") list(53.88:14.92 54.09:15.14))
dbCreateRect(cvid list("CONT" "drawing") list(53.88:15.39 54.09:15.61))
dbCreateRect(cvid list("CONT" "drawing") list(53.88:15.86 54.09:16.07))
dbCreateRect(cvid list("CONT" "drawing") list(53.88:16.33 54.09:16.55))
dbCreateRect(cvid list("CONT" "drawing") list(53.88:16.80 54.09:17.02))
dbCreateRect(cvid list("CONT" "drawing") list(53.88:17.27 54.09:17.48))
dbCreateRect(cvid list("CONT" "drawing") list(53.88:17.73 54.09:17.95))
dbCreateRect(cvid list("CONT" "drawing") list(53.88:18.21 54.09:18.43))
dbCreateRect(cvid list("CONT" "drawing") list(53.88:18.68 54.09:18.89))
dbCreateRect(cvid list("CONT" "drawing") list(53.88:19.15 54.09:19.37))
dbCreateRect(cvid list("PIMP" "drawing") list(53.58:3.54 54.40:19.93))
dbCreateRect(cvid list("DIFF" "drawing") list(44.96:19.75 53.76:20.21))
dbCreateRect(cvid list("METAL1" "drawing") list(44.96:19.75 53.76:20.21))
dbCreateRect(cvid list("CONT" "drawing") list(45.49:19.87 45.71:20.09))
dbCreateRect(cvid list("CONT" "drawing") list(45.96:19.87 46.18:20.09))
dbCreateRect(cvid list("CONT" "drawing") list(46.43:19.87 46.65:20.09))
dbCreateRect(cvid list("CONT" "drawing") list(46.90:19.87 47.12:20.09))
dbCreateRect(cvid list("CONT" "drawing") list(47.37:19.87 47.59:20.09))
dbCreateRect(cvid list("CONT" "drawing") list(47.84:19.87 48.06:20.09))
dbCreateRect(cvid list("CONT" "drawing") list(48.31:19.87 48.53:20.09))
dbCreateRect(cvid list("CONT" "drawing") list(48.78:19.87 49.00:20.09))
dbCreateRect(cvid list("CONT" "drawing") list(49.25:19.87 49.47:20.09))
dbCreateRect(cvid list("CONT" "drawing") list(49.72:19.87 49.94:20.09))
dbCreateRect(cvid list("CONT" "drawing") list(50.19:19.87 50.41:20.09))
dbCreateRect(cvid list("CONT" "drawing") list(50.66:19.87 50.88:20.09))
dbCreateRect(cvid list("CONT" "drawing") list(51.13:19.87 51.35:20.09))
dbCreateRect(cvid list("CONT" "drawing") list(51.60:19.87 51.82:20.09))
dbCreateRect(cvid list("CONT" "drawing") list(52.07:19.87 52.29:20.09))
dbCreateRect(cvid list("CONT" "drawing") list(52.54:19.87 52.76:20.09))
dbCreateRect(cvid list("CONT" "drawing") list(53.01:19.87 53.23:20.09))
dbCreateRect(cvid list("PIMP" "drawing") list(44.78:19.57 53.94:20.39))
dbCreateParamInst(cvid masternmos "I55" list(31.245 4.500) "MY" 1 list(list("w" "string" "15.00u") list("l" "string" "1.20u") ))
dbCreateParamInst(cvid masternmos "M7.1" list(31.785 4.500) "R0" 1 list(list("w" "string" "15.00u") list("l" "string" "1.20u") ))
dbCreateParamInst(cvid masternmos "M7.2" list(34.725 4.500) "MY" 1 list(list("w" "string" "15.00u") list("l" "string" "1.20u") ))
dbCreateParamInst(cvid masternmos "M7.3" list(35.265 4.500) "R0" 1 list(list("w" "string" "15.00u") list("l" "string" "1.20u") ))
dbCreateParamInst(cvid masternmos "M7.4" list(38.205 4.500) "MY" 1 list(list("w" "string" "15.00u") list("l" "string" "1.20u") ))
dbCreateParamInst(cvid masternmos "I54" list(38.745 4.500) "R0" 1 list(list("w" "string" "15.00u") list("l" "string" "1.20u") ))
dbCreateRect(cvid list("METAL1" "drawing") list(29.57:4.50 29.97:19.50))
dbCreateRect(cvid list("METAL1" "drawing") list(31.32:4.50 31.71:19.50))
dbCreateRect(cvid list("METAL1" "drawing") list(33.05:4.50 33.46:19.50))
dbCreateRect(cvid list("METAL1" "drawing") list(34.80:4.50 35.20:19.50))
dbCreateRect(cvid list("METAL1" "drawing") list(36.53:4.50 36.94:19.50))
dbCreateRect(cvid list("METAL1" "drawing") list(38.27:4.50 38.68:19.50))
dbCreateRect(cvid list("METAL1" "drawing") list(40.01:4.50 40.41:19.50))
dbCreateRect(cvid list("POLY1" "drawing") list(30.05:19.72 31.25:20.14))
dbCreateRect(cvid list("METAL1" "drawing") list(30.17:19.72 31.12:20.14))
dbCreateRect(cvid list("CONT" "drawing") list(30.54:19.82 30.76:20.04))
dbCreateRect(cvid list("POLY1" "drawing") list(31.79:19.72 32.99:20.14))
dbCreateRect(cvid list("METAL1" "drawing") list(31.91:19.72 32.86:20.14))
dbCreateRect(cvid list("CONT" "drawing") list(32.28:19.82 32.50:20.04))
dbCreateRect(cvid list("POLY1" "drawing") list(33.52:19.72 34.73:20.14))
dbCreateRect(cvid list("METAL1" "drawing") list(33.65:19.72 34.60:20.14))
dbCreateRect(cvid list("CONT" "drawing") list(34.02:19.82 34.23:20.04))
dbCreateRect(cvid list("POLY1" "drawing") list(35.27:19.72 36.47:20.14))
dbCreateRect(cvid list("METAL1" "drawing") list(35.39:19.72 36.34:20.14))
dbCreateRect(cvid list("CONT" "drawing") list(35.76:19.82 35.98:20.04))
dbCreateRect(cvid list("POLY1" "drawing") list(37.00:19.72 38.20:20.14))
dbCreateRect(cvid list("METAL1" "drawing") list(37.13:19.72 38.08:20.14))
dbCreateRect(cvid list("CONT" "drawing") list(37.49:19.82 37.71:20.04))
dbCreateRect(cvid list("POLY1" "drawing") list(38.74:19.72 39.95:20.14))
dbCreateRect(cvid list("METAL1" "drawing") list(38.87:19.72 39.82:20.14))
dbCreateRect(cvid list("CONT" "drawing") list(39.23:19.82 39.45:20.04))
dbCreateRect(cvid list("DIFF" "drawing") list(28.39:3.33 28.86:3.79))
dbCreateRect(cvid list("METAL1" "drawing") list(28.39:3.33 28.86:3.79))
dbCreateRect(cvid list("CONT" "drawing") list(28.52:3.45 28.73:3.67))
dbCreateRect(cvid list("PIMP" "drawing") list(28.21:3.15 29.04:3.97))
dbCreateRect(cvid list("DIFF" "drawing") list(41.13:3.33 41.59:3.79))
dbCreateRect(cvid list("METAL1" "drawing") list(41.13:3.33 41.59:3.79))
dbCreateRect(cvid list("CONT" "drawing") list(41.25:3.45 41.47:3.67))
dbCreateRect(cvid list("PIMP" "drawing") list(40.95:3.15 41.77:3.97))
dbCreateRect(cvid list("DIFF" "drawing") list(28.39:20.42 28.86:20.88))
dbCreateRect(cvid list("METAL1" "drawing") list(28.39:20.42 28.86:20.88))
dbCreateRect(cvid list("CONT" "drawing") list(28.52:20.54 28.73:20.76))
dbCreateRect(cvid list("PIMP" "drawing") list(28.21:20.24 29.04:21.06))
dbCreateRect(cvid list("DIFF" "drawing") list(41.13:20.42 41.59:20.88))
dbCreateRect(cvid list("METAL1" "drawing") list(41.13:20.42 41.59:20.88))
dbCreateRect(cvid list("CONT" "drawing") list(41.25:20.54 41.47:20.76))
dbCreateRect(cvid list("PIMP" "drawing") list(40.95:20.24 41.77:21.06))
dbCreateRect(cvid list("DIFF" "drawing") list(28.39:3.79 28.86:20.42))
dbCreateRect(cvid list("METAL1" "drawing") list(28.39:3.79 28.86:20.42))
dbCreateRect(cvid list("CONT" "drawing") list(28.52:4.01 28.73:4.23))
dbCreateRect(cvid list("CONT" "drawing") list(28.52:4.48 28.73:4.70))
dbCreateRect(cvid list("CONT" "drawing") list(28.52:4.95 28.73:5.17))
dbCreateRect(cvid list("CONT" "drawing") list(28.52:5.42 28.73:5.64))
dbCreateRect(cvid list("CONT" "drawing") list(28.52:5.89 28.73:6.11))
dbCreateRect(cvid list("CONT" "drawing") list(28.52:6.36 28.73:6.58))
dbCreateRect(cvid list("CONT" "drawing") list(28.52:6.83 28.73:7.05))
dbCreateRect(cvid list("CONT" "drawing") list(28.52:7.30 28.73:7.52))
dbCreateRect(cvid list("CONT" "drawing") list(28.52:7.77 28.73:7.99))
dbCreateRect(cvid list("CONT" "drawing") list(28.52:8.24 28.73:8.46))
dbCreateRect(cvid list("CONT" "drawing") list(28.52:8.71 28.73:8.93))
dbCreateRect(cvid list("CONT" "drawing") list(28.52:9.18 28.73:9.40))
dbCreateRect(cvid list("CONT" "drawing") list(28.52:9.65 28.73:9.87))
dbCreateRect(cvid list("CONT" "drawing") list(28.52:10.12 28.73:10.34))
dbCreateRect(cvid list("CONT" "drawing") list(28.52:10.59 28.73:10.81))
dbCreateRect(cvid list("CONT" "drawing") list(28.52:11.06 28.73:11.28))
dbCreateRect(cvid list("CONT" "drawing") list(28.52:11.53 28.73:11.75))
dbCreateRect(cvid list("CONT" "drawing") list(28.52:12.00 28.73:12.22))
dbCreateRect(cvid list("CONT" "drawing") list(28.52:12.47 28.73:12.69))
dbCreateRect(cvid list("CONT" "drawing") list(28.52:12.94 28.73:13.16))
dbCreateRect(cvid list("CONT" "drawing") list(28.52:13.41 28.73:13.63))
dbCreateRect(cvid list("CONT" "drawing") list(28.52:13.88 28.73:14.10))
dbCreateRect(cvid list("CONT" "drawing") list(28.52:14.35 28.73:14.57))
dbCreateRect(cvid list("CONT" "drawing") list(28.52:14.82 28.73:15.04))
dbCreateRect(cvid list("CONT" "drawing") list(28.52:15.29 28.73:15.51))
dbCreateRect(cvid list("CONT" "drawing") list(28.52:15.76 28.73:15.98))
dbCreateRect(cvid list("CONT" "drawing") list(28.52:16.23 28.73:16.45))
dbCreateRect(cvid list("CONT" "drawing") list(28.52:16.70 28.73:16.92))
dbCreateRect(cvid list("CONT" "drawing") list(28.52:17.17 28.73:17.39))
dbCreateRect(cvid list("CONT" "drawing") list(28.52:17.64 28.73:17.86))
dbCreateRect(cvid list("CONT" "drawing") list(28.52:18.11 28.73:18.33))
dbCreateRect(cvid list("CONT" "drawing") list(28.52:18.58 28.73:18.80))
dbCreateRect(cvid list("CONT" "drawing") list(28.52:19.05 28.73:19.27))
dbCreateRect(cvid list("CONT" "drawing") list(28.52:19.52 28.73:19.74))
dbCreateRect(cvid list("CONT" "drawing") list(28.52:19.99 28.73:20.21))
dbCreateRect(cvid list("PIMP" "drawing") list(28.21:3.61 29.04:20.60))
dbCreateRect(cvid list("DIFF" "drawing") list(28.86:3.33 41.13:3.79))
dbCreateRect(cvid list("METAL1" "drawing") list(28.86:3.33 41.13:3.79))
dbCreateRect(cvid list("CONT" "drawing") list(29.24:3.45 29.46:3.67))
dbCreateRect(cvid list("CONT" "drawing") list(29.71:3.45 29.93:3.67))
dbCreateRect(cvid list("CONT" "drawing") list(30.18:3.45 30.40:3.67))
dbCreateRect(cvid list("CONT" "drawing") list(30.65:3.45 30.87:3.67))
dbCreateRect(cvid list("CONT" "drawing") list(31.12:3.45 31.34:3.67))
dbCreateRect(cvid list("CONT" "drawing") list(31.59:3.45 31.81:3.67))
dbCreateRect(cvid list("CONT" "drawing") list(32.06:3.45 32.28:3.67))
dbCreateRect(cvid list("CONT" "drawing") list(32.53:3.45 32.75:3.67))
dbCreateRect(cvid list("CONT" "drawing") list(33.00:3.45 33.22:3.67))
dbCreateRect(cvid list("CONT" "drawing") list(33.48:3.45 33.70:3.67))
dbCreateRect(cvid list("CONT" "drawing") list(33.95:3.45 34.16:3.67))
dbCreateRect(cvid list("CONT" "drawing") list(34.41:3.45 34.63:3.67))
dbCreateRect(cvid list("CONT" "drawing") list(34.88:3.45 35.10:3.67))
dbCreateRect(cvid list("CONT" "drawing") list(35.35:3.45 35.57:3.67))
dbCreateRect(cvid list("CONT" "drawing") list(35.82:3.45 36.04:3.67))
dbCreateRect(cvid list("CONT" "drawing") list(36.29:3.45 36.51:3.67))
dbCreateRect(cvid list("CONT" "drawing") list(36.77:3.45 36.98:3.67))
dbCreateRect(cvid list("CONT" "drawing") list(37.23:3.45 37.45:3.67))
dbCreateRect(cvid list("CONT" "drawing") list(37.70:3.45 37.92:3.67))
dbCreateRect(cvid list("CONT" "drawing") list(38.17:3.45 38.39:3.67))
dbCreateRect(cvid list("CONT" "drawing") list(38.64:3.45 38.86:3.67))
dbCreateRect(cvid list("CONT" "drawing") list(39.11:3.45 39.33:3.67))
dbCreateRect(cvid list("CONT" "drawing") list(39.58:3.45 39.80:3.67))
dbCreateRect(cvid list("CONT" "drawing") list(40.05:3.45 40.27:3.67))
dbCreateRect(cvid list("CONT" "drawing") list(40.52:3.45 40.74:3.67))
dbCreateRect(cvid list("PIMP" "drawing") list(28.68:3.15 41.31:3.97))
dbCreateRect(cvid list("DIFF" "drawing") list(41.13:3.79 41.59:20.42))
dbCreateRect(cvid list("METAL1" "drawing") list(41.13:3.79 41.59:20.42))
dbCreateRect(cvid list("CONT" "drawing") list(41.25:4.01 41.47:4.23))
dbCreateRect(cvid list("CONT" "drawing") list(41.25:4.48 41.47:4.70))
dbCreateRect(cvid list("CONT" "drawing") list(41.25:4.95 41.47:5.17))
dbCreateRect(cvid list("CONT" "drawing") list(41.25:5.42 41.47:5.64))
dbCreateRect(cvid list("CONT" "drawing") list(41.25:5.89 41.47:6.11))
dbCreateRect(cvid list("CONT" "drawing") list(41.25:6.36 41.47:6.58))
dbCreateRect(cvid list("CONT" "drawing") list(41.25:6.83 41.47:7.05))
dbCreateRect(cvid list("CONT" "drawing") list(41.25:7.30 41.47:7.52))
dbCreateRect(cvid list("CONT" "drawing") list(41.25:7.77 41.47:7.99))
dbCreateRect(cvid list("CONT" "drawing") list(41.25:8.24 41.47:8.46))
dbCreateRect(cvid list("CONT" "drawing") list(41.25:8.71 41.47:8.93))
dbCreateRect(cvid list("CONT" "drawing") list(41.25:9.18 41.47:9.40))
dbCreateRect(cvid list("CONT" "drawing") list(41.25:9.65 41.47:9.87))
dbCreateRect(cvid list("CONT" "drawing") list(41.25:10.12 41.47:10.34))
dbCreateRect(cvid list("CONT" "drawing") list(41.25:10.59 41.47:10.81))
dbCreateRect(cvid list("CONT" "drawing") list(41.25:11.06 41.47:11.28))
dbCreateRect(cvid list("CONT" "drawing") list(41.25:11.53 41.47:11.75))
dbCreateRect(cvid list("CONT" "drawing") list(41.25:12.00 41.47:12.22))
dbCreateRect(cvid list("CONT" "drawing") list(41.25:12.47 41.47:12.69))
dbCreateRect(cvid list("CONT" "drawing") list(41.25:12.94 41.47:13.16))
dbCreateRect(cvid list("CONT" "drawing") list(41.25:13.41 41.47:13.63))
dbCreateRect(cvid list("CONT" "drawing") list(41.25:13.88 41.47:14.10))
dbCreateRect(cvid list("CONT" "drawing") list(41.25:14.35 41.47:14.57))
dbCreateRect(cvid list("CONT" "drawing") list(41.25:14.82 41.47:15.04))
dbCreateRect(cvid list("CONT" "drawing") list(41.25:15.29 41.47:15.51))
dbCreateRect(cvid list("CONT" "drawing") list(41.25:15.76 41.47:15.98))
dbCreateRect(cvid list("CONT" "drawing") list(41.25:16.23 41.47:16.45))
dbCreateRect(cvid list("CONT" "drawing") list(41.25:16.70 41.47:16.92))
dbCreateRect(cvid list("CONT" "drawing") list(41.25:17.17 41.47:17.39))
dbCreateRect(cvid list("CONT" "drawing") list(41.25:17.64 41.47:17.86))
dbCreateRect(cvid list("CONT" "drawing") list(41.25:18.11 41.47:18.33))
dbCreateRect(cvid list("CONT" "drawing") list(41.25:18.58 41.47:18.80))
dbCreateRect(cvid list("CONT" "drawing") list(41.25:19.05 41.47:19.27))
dbCreateRect(cvid list("CONT" "drawing") list(41.25:19.52 41.47:19.74))
dbCreateRect(cvid list("CONT" "drawing") list(41.25:19.99 41.47:20.21))
dbCreateRect(cvid list("PIMP" "drawing") list(40.95:3.61 41.77:20.60))
dbCreateRect(cvid list("DIFF" "drawing") list(28.86:20.42 41.13:20.88))
dbCreateRect(cvid list("METAL1" "drawing") list(28.86:20.42 41.13:20.88))
dbCreateRect(cvid list("CONT" "drawing") list(29.24:20.54 29.46:20.76))
dbCreateRect(cvid list("CONT" "drawing") list(29.71:20.54 29.93:20.76))
dbCreateRect(cvid list("CONT" "drawing") list(30.18:20.54 30.40:20.76))
dbCreateRect(cvid list("CONT" "drawing") list(30.65:20.54 30.87:20.76))
dbCreateRect(cvid list("CONT" "drawing") list(31.12:20.54 31.34:20.76))
dbCreateRect(cvid list("CONT" "drawing") list(31.59:20.54 31.81:20.76))
dbCreateRect(cvid list("CONT" "drawing") list(32.06:20.54 32.28:20.76))
dbCreateRect(cvid list("CONT" "drawing") list(32.53:20.54 32.75:20.76))
dbCreateRect(cvid list("CONT" "drawing") list(33.00:20.54 33.22:20.76))
dbCreateRect(cvid list("CONT" "drawing") list(33.48:20.54 33.70:20.76))
dbCreateRect(cvid list("CONT" "drawing") list(33.95:20.54 34.16:20.76))
dbCreateRect(cvid list("CONT" "drawing") list(34.41:20.54 34.63:20.76))
dbCreateRect(cvid list("CONT" "drawing") list(34.88:20.54 35.10:20.76))
dbCreateRect(cvid list("CONT" "drawing") list(35.35:20.54 35.57:20.76))
dbCreateRect(cvid list("CONT" "drawing") list(35.82:20.54 36.04:20.76))
dbCreateRect(cvid list("CONT" "drawing") list(36.29:20.54 36.51:20.76))
dbCreateRect(cvid list("CONT" "drawing") list(36.77:20.54 36.98:20.76))
dbCreateRect(cvid list("CONT" "drawing") list(37.23:20.54 37.45:20.76))
dbCreateRect(cvid list("CONT" "drawing") list(37.70:20.54 37.92:20.76))
dbCreateRect(cvid list("CONT" "drawing") list(38.17:20.54 38.39:20.76))
dbCreateRect(cvid list("CONT" "drawing") list(38.64:20.54 38.86:20.76))
dbCreateRect(cvid list("CONT" "drawing") list(39.11:20.54 39.33:20.76))
dbCreateRect(cvid list("CONT" "drawing") list(39.58:20.54 39.80:20.76))
dbCreateRect(cvid list("CONT" "drawing") list(40.05:20.54 40.27:20.76))
dbCreateRect(cvid list("CONT" "drawing") list(40.52:20.54 40.74:20.76))
dbCreateRect(cvid list("PIMP" "drawing") list(28.68:20.24 41.31:21.06))
dbCreateParamInst(cvid masterres "R2" list(83.090 17.665) "MXR90" 1 list(list("w" "string" "1.00u") list("l" "string" "2.10u") list("segments" "string" "2") ))
dbCreateRect(cvid list("DIFF" "drawing") list(82.13:16.74 82.59:17.20))
dbCreateRect(cvid list("METAL1" "drawing") list(82.13:16.74 82.59:17.20))
dbCreateRect(cvid list("CONT" "drawing") list(82.25:16.86 82.47:17.08))
dbCreateRect(cvid list("NIMP" "drawing") list(81.95:16.56 82.77:17.38))
dbCreateRect(cvid list("NWELL" "drawing") list(81.70:16.31 83.02:17.63))
dbCreateRect(cvid list("DIFF" "drawing") list(85.84:16.74 86.30:17.20))
dbCreateRect(cvid list("METAL1" "drawing") list(85.84:16.74 86.30:17.20))
dbCreateRect(cvid list("CONT" "drawing") list(85.96:16.86 86.18:17.08))
dbCreateRect(cvid list("NIMP" "drawing") list(85.66:16.56 86.48:17.38))
dbCreateRect(cvid list("NWELL" "drawing") list(85.41:16.31 86.73:17.63))
dbCreateRect(cvid list("DIFF" "drawing") list(82.13:21.30 82.59:21.77))
dbCreateRect(cvid list("METAL1" "drawing") list(82.13:21.30 82.59:21.77))
dbCreateRect(cvid list("CONT" "drawing") list(82.25:21.43 82.47:21.64))
dbCreateRect(cvid list("NIMP" "drawing") list(81.95:21.12 82.77:21.95))
dbCreateRect(cvid list("NWELL" "drawing") list(81.70:20.88 83.02:22.20))
dbCreateRect(cvid list("DIFF" "drawing") list(85.84:21.30 86.30:21.77))
dbCreateRect(cvid list("METAL1" "drawing") list(85.84:21.30 86.30:21.77))
dbCreateRect(cvid list("CONT" "drawing") list(85.96:21.43 86.18:21.64))
dbCreateRect(cvid list("NIMP" "drawing") list(85.66:21.12 86.48:21.95))
dbCreateRect(cvid list("NWELL" "drawing") list(85.41:20.88 86.73:22.20))
dbCreateRect(cvid list("DIFF" "drawing") list(82.13:17.20 82.59:21.30))
dbCreateRect(cvid list("METAL1" "drawing") list(82.13:17.20 82.59:21.30))
dbCreateRect(cvid list("CONT" "drawing") list(82.25:17.73 82.47:17.95))
dbCreateRect(cvid list("CONT" "drawing") list(82.25:18.20 82.47:18.42))
dbCreateRect(cvid list("CONT" "drawing") list(82.25:18.68 82.47:18.89))
dbCreateRect(cvid list("CONT" "drawing") list(82.25:19.14 82.47:19.36))
dbCreateRect(cvid list("CONT" "drawing") list(82.25:19.61 82.47:19.83))
dbCreateRect(cvid list("CONT" "drawing") list(82.25:20.09 82.47:20.30))
dbCreateRect(cvid list("CONT" "drawing") list(82.25:20.55 82.47:20.77))
dbCreateRect(cvid list("NIMP" "drawing") list(81.95:17.02 82.77:21.48))
dbCreateRect(cvid list("NWELL" "drawing") list(81.70:16.77 83.02:21.73))
dbCreateRect(cvid list("DIFF" "drawing") list(82.59:16.74 85.84:17.20))
dbCreateRect(cvid list("METAL1" "drawing") list(82.59:16.74 85.84:17.20))
dbCreateRect(cvid list("CONT" "drawing") list(82.70:16.86 82.92:17.08))
dbCreateRect(cvid list("CONT" "drawing") list(83.17:16.86 83.39:17.08))
dbCreateRect(cvid list("CONT" "drawing") list(83.64:16.86 83.86:17.08))
dbCreateRect(cvid list("CONT" "drawing") list(84.11:16.86 84.33:17.08))
dbCreateRect(cvid list("CONT" "drawing") list(84.58:16.86 84.80:17.08))
dbCreateRect(cvid list("CONT" "drawing") list(85.05:16.86 85.27:17.08))
dbCreateRect(cvid list("CONT" "drawing") list(85.52:16.86 85.73:17.08))
dbCreateRect(cvid list("NIMP" "drawing") list(82.41:16.56 86.02:17.38))
dbCreateRect(cvid list("NWELL" "drawing") list(82.16:16.31 86.27:17.63))
dbCreateRect(cvid list("DIFF" "drawing") list(85.84:17.20 86.30:21.30))
dbCreateRect(cvid list("METAL1" "drawing") list(85.84:17.20 86.30:21.30))
dbCreateRect(cvid list("CONT" "drawing") list(85.96:17.73 86.18:17.95))
dbCreateRect(cvid list("CONT" "drawing") list(85.96:18.20 86.18:18.42))
dbCreateRect(cvid list("CONT" "drawing") list(85.96:18.68 86.18:18.89))
dbCreateRect(cvid list("CONT" "drawing") list(85.96:19.14 86.18:19.36))
dbCreateRect(cvid list("CONT" "drawing") list(85.96:19.61 86.18:19.83))
dbCreateRect(cvid list("CONT" "drawing") list(85.96:20.09 86.18:20.30))
dbCreateRect(cvid list("CONT" "drawing") list(85.96:20.55 86.18:20.77))
dbCreateRect(cvid list("NIMP" "drawing") list(85.66:17.02 86.48:21.48))
dbCreateRect(cvid list("NWELL" "drawing") list(85.41:16.77 86.73:21.73))
dbCreateRect(cvid list("DIFF" "drawing") list(82.59:21.30 85.84:21.77))
dbCreateRect(cvid list("METAL1" "drawing") list(82.59:21.30 85.84:21.77))
dbCreateRect(cvid list("CONT" "drawing") list(82.70:21.43 82.92:21.64))
dbCreateRect(cvid list("CONT" "drawing") list(83.17:21.43 83.39:21.64))
dbCreateRect(cvid list("CONT" "drawing") list(83.64:21.43 83.86:21.64))
dbCreateRect(cvid list("CONT" "drawing") list(84.11:21.43 84.33:21.64))
dbCreateRect(cvid list("CONT" "drawing") list(84.58:21.43 84.80:21.64))
dbCreateRect(cvid list("CONT" "drawing") list(85.05:21.43 85.27:21.64))
dbCreateRect(cvid list("CONT" "drawing") list(85.52:21.43 85.73:21.64))
dbCreateRect(cvid list("NIMP" "drawing") list(82.41:21.12 86.02:21.95))
dbCreateRect(cvid list("NWELL" "drawing") list(82.16:20.88 86.27:22.20))
dbCreateParamInst(cvid masterres "R3" list(58.475 20.870) "MYR90" 1 list(list("w" "string" "1.00u") list("l" "string" "2.38u") list("segments" "string" "2") ))
dbCreateRect(cvid list("DIFF" "drawing") list(55.27:16.49 55.73:16.95))
dbCreateRect(cvid list("METAL1" "drawing") list(55.27:16.49 55.73:16.95))
dbCreateRect(cvid list("CONT" "drawing") list(55.39:16.61 55.61:16.83))
dbCreateRect(cvid list("NIMP" "drawing") list(55.09:16.31 55.91:17.13))
dbCreateRect(cvid list("NWELL" "drawing") list(54.84:16.06 56.16:17.38))
dbCreateRect(cvid list("DIFF" "drawing") list(58.98:16.49 59.44:16.95))
dbCreateRect(cvid list("METAL1" "drawing") list(58.98:16.49 59.44:16.95))
dbCreateRect(cvid list("CONT" "drawing") list(59.09:16.61 59.31:16.83))
dbCreateRect(cvid list("NIMP" "drawing") list(58.80:16.31 59.62:17.13))
dbCreateRect(cvid list("NWELL" "drawing") list(58.55:16.06 59.87:17.38))
dbCreateRect(cvid list("DIFF" "drawing") list(55.27:21.33 55.73:21.79))
dbCreateRect(cvid list("METAL1" "drawing") list(55.27:21.33 55.73:21.79))
dbCreateRect(cvid list("CONT" "drawing") list(55.39:21.45 55.61:21.67))
dbCreateRect(cvid list("NIMP" "drawing") list(55.09:21.15 55.91:21.97))
dbCreateRect(cvid list("NWELL" "drawing") list(54.84:20.90 56.16:22.22))
dbCreateRect(cvid list("DIFF" "drawing") list(58.98:21.33 59.44:21.79))
dbCreateRect(cvid list("METAL1" "drawing") list(58.98:21.33 59.44:21.79))
dbCreateRect(cvid list("CONT" "drawing") list(59.09:21.45 59.31:21.67))
dbCreateRect(cvid list("NIMP" "drawing") list(58.80:21.15 59.62:21.97))
dbCreateRect(cvid list("NWELL" "drawing") list(58.55:20.90 59.87:22.22))
dbCreateRect(cvid list("DIFF" "drawing") list(55.27:16.95 55.73:21.33))
dbCreateRect(cvid list("METAL1" "drawing") list(55.27:16.95 55.73:21.33))
dbCreateRect(cvid list("CONT" "drawing") list(55.39:17.15 55.61:17.37))
dbCreateRect(cvid list("CONT" "drawing") list(55.39:17.62 55.61:17.84))
dbCreateRect(cvid list("CONT" "drawing") list(55.39:18.09 55.61:18.31))
dbCreateRect(cvid list("CONT" "drawing") list(55.39:18.56 55.61:18.78))
dbCreateRect(cvid list("CONT" "drawing") list(55.39:19.03 55.61:19.25))
dbCreateRect(cvid list("CONT" "drawing") list(55.39:19.50 55.61:19.72))
dbCreateRect(cvid list("CONT" "drawing") list(55.39:19.97 55.61:20.19))
dbCreateRect(cvid list("CONT" "drawing") list(55.39:20.44 55.61:20.66))
dbCreateRect(cvid list("CONT" "drawing") list(55.39:20.91 55.61:21.13))
dbCreateRect(cvid list("NIMP" "drawing") list(55.09:16.77 55.91:21.51))
dbCreateRect(cvid list("NWELL" "drawing") list(54.84:16.52 56.16:21.76))
dbCreateRect(cvid list("DIFF" "drawing") list(55.73:16.49 58.98:16.95))
dbCreateRect(cvid list("METAL1" "drawing") list(55.73:16.49 58.98:16.95))
dbCreateRect(cvid list("CONT" "drawing") list(55.83:16.61 56.05:16.83))
dbCreateRect(cvid list("CONT" "drawing") list(56.30:16.61 56.52:16.83))
dbCreateRect(cvid list("CONT" "drawing") list(56.77:16.61 56.99:16.83))
dbCreateRect(cvid list("CONT" "drawing") list(57.24:16.61 57.46:16.83))
dbCreateRect(cvid list("CONT" "drawing") list(57.71:16.61 57.93:16.83))
dbCreateRect(cvid list("CONT" "drawing") list(58.18:16.61 58.40:16.83))
dbCreateRect(cvid list("CONT" "drawing") list(58.65:16.61 58.87:16.83))
dbCreateRect(cvid list("NIMP" "drawing") list(55.55:16.31 59.16:17.13))
dbCreateRect(cvid list("NWELL" "drawing") list(55.30:16.06 59.41:17.38))
dbCreateRect(cvid list("DIFF" "drawing") list(58.98:16.95 59.44:21.33))
dbCreateRect(cvid list("METAL1" "drawing") list(58.98:16.95 59.44:21.33))
dbCreateRect(cvid list("CONT" "drawing") list(59.09:17.15 59.31:17.37))
dbCreateRect(cvid list("CONT" "drawing") list(59.09:17.62 59.31:17.84))
dbCreateRect(cvid list("CONT" "drawing") list(59.09:18.09 59.31:18.31))
dbCreateRect(cvid list("CONT" "drawing") list(59.09:18.56 59.31:18.78))
dbCreateRect(cvid list("CONT" "drawing") list(59.09:19.03 59.31:19.25))
dbCreateRect(cvid list("CONT" "drawing") list(59.09:19.50 59.31:19.72))
dbCreateRect(cvid list("CONT" "drawing") list(59.09:19.97 59.31:20.19))
dbCreateRect(cvid list("CONT" "drawing") list(59.09:20.44 59.31:20.66))
dbCreateRect(cvid list("CONT" "drawing") list(59.09:20.91 59.31:21.13))
dbCreateRect(cvid list("NIMP" "drawing") list(58.80:16.77 59.62:21.51))
dbCreateRect(cvid list("NWELL" "drawing") list(58.55:16.52 59.87:21.76))
dbCreateRect(cvid list("DIFF" "drawing") list(55.73:21.33 58.98:21.79))
dbCreateRect(cvid list("METAL1" "drawing") list(55.73:21.33 58.98:21.79))
dbCreateRect(cvid list("CONT" "drawing") list(55.83:21.45 56.05:21.67))
dbCreateRect(cvid list("CONT" "drawing") list(56.30:21.45 56.52:21.67))
dbCreateRect(cvid list("CONT" "drawing") list(56.77:21.45 56.99:21.67))
dbCreateRect(cvid list("CONT" "drawing") list(57.24:21.45 57.46:21.67))
dbCreateRect(cvid list("CONT" "drawing") list(57.71:21.45 57.93:21.67))
dbCreateRect(cvid list("CONT" "drawing") list(58.18:21.45 58.40:21.67))
dbCreateRect(cvid list("CONT" "drawing") list(58.65:21.45 58.87:21.67))
dbCreateRect(cvid list("NIMP" "drawing") list(55.55:21.15 59.16:21.97))
dbCreateRect(cvid list("NWELL" "drawing") list(55.30:20.90 59.41:22.22))
dbCreateParamInst(cvid mastercap "C1.2" list(30.615 23.460) "R0" 1 list(list("w" "string" "28.00u") list("l" "string" "28.00u") ))
dbCreateParamInst(cvid mastercap "C1.1" list(63.415 23.460) "R0" 1 list(list("w" "string" "28.00u") list("l" "string" "28.00u") ))
dbCreateRect(cvid list("METAL2" "drawing") list(0.00:72.00 100.00:80.00))
dbCreateRect(cvid list("METAL2" "drawing") list(28.39:0.00 100.00:8.00))
dbCreateRect(cvid list("METAL2" "drawing") list(2.11:72.00 2.51:77.17))
dbCreateRect(cvid list("VIA12" "drawing") list(2.18:72.38 2.44:72.64))
dbCreateRect(cvid list("VIA12" "drawing") list(2.18:72.90 2.44:73.16))
dbCreateRect(cvid list("VIA12" "drawing") list(2.18:73.42 2.44:73.68))
dbCreateRect(cvid list("VIA12" "drawing") list(2.18:73.94 2.44:74.20))
dbCreateRect(cvid list("VIA12" "drawing") list(2.18:74.46 2.44:74.72))
dbCreateRect(cvid list("VIA12" "drawing") list(2.18:74.98 2.44:75.24))
dbCreateRect(cvid list("VIA12" "drawing") list(2.18:75.50 2.44:75.76))
dbCreateRect(cvid list("VIA12" "drawing") list(2.18:76.02 2.44:76.28))
dbCreateRect(cvid list("VIA12" "drawing") list(2.18:76.54 2.44:76.80))
dbCreateRect(cvid list("METAL2" "drawing") list(4.65:72.00 5.05:77.17))
dbCreateRect(cvid list("VIA12" "drawing") list(4.72:72.38 4.98:72.64))
dbCreateRect(cvid list("VIA12" "drawing") list(4.72:72.90 4.98:73.16))
dbCreateRect(cvid list("VIA12" "drawing") list(4.72:73.42 4.98:73.68))
dbCreateRect(cvid list("VIA12" "drawing") list(4.72:73.94 4.98:74.20))
dbCreateRect(cvid list("VIA12" "drawing") list(4.72:74.46 4.98:74.72))
dbCreateRect(cvid list("VIA12" "drawing") list(4.72:74.98 4.98:75.24))
dbCreateRect(cvid list("VIA12" "drawing") list(4.72:75.50 4.98:75.76))
dbCreateRect(cvid list("VIA12" "drawing") list(4.72:76.02 4.98:76.28))
dbCreateRect(cvid list("VIA12" "drawing") list(4.72:76.54 4.98:76.80))
dbCreateRect(cvid list("METAL2" "drawing") list(9.73:72.00 10.13:77.17))
dbCreateRect(cvid list("VIA12" "drawing") list(9.80:72.38 10.06:72.64))
dbCreateRect(cvid list("VIA12" "drawing") list(9.80:72.90 10.06:73.16))
dbCreateRect(cvid list("VIA12" "drawing") list(9.80:73.42 10.06:73.68))
dbCreateRect(cvid list("VIA12" "drawing") list(9.80:73.94 10.06:74.20))
dbCreateRect(cvid list("VIA12" "drawing") list(9.80:74.46 10.06:74.72))
dbCreateRect(cvid list("VIA12" "drawing") list(9.80:74.98 10.06:75.24))
dbCreateRect(cvid list("VIA12" "drawing") list(9.80:75.50 10.06:75.76))
dbCreateRect(cvid list("VIA12" "drawing") list(9.80:76.02 10.06:76.28))
dbCreateRect(cvid list("VIA12" "drawing") list(9.80:76.54 10.06:76.80))
dbCreateRect(cvid list("METAL2" "drawing") list(14.81:72.00 15.21:77.17))
dbCreateRect(cvid list("VIA12" "drawing") list(14.88:72.38 15.14:72.64))
dbCreateRect(cvid list("VIA12" "drawing") list(14.88:72.90 15.14:73.16))
dbCreateRect(cvid list("VIA12" "drawing") list(14.88:73.42 15.14:73.68))
dbCreateRect(cvid list("VIA12" "drawing") list(14.88:73.94 15.14:74.20))
dbCreateRect(cvid list("VIA12" "drawing") list(14.88:74.46 15.14:74.72))
dbCreateRect(cvid list("VIA12" "drawing") list(14.88:74.98 15.14:75.24))
dbCreateRect(cvid list("VIA12" "drawing") list(14.88:75.50 15.14:75.76))
dbCreateRect(cvid list("VIA12" "drawing") list(14.88:76.02 15.14:76.28))
dbCreateRect(cvid list("VIA12" "drawing") list(14.88:76.54 15.14:76.80))
dbCreateRect(cvid list("METAL2" "drawing") list(19.89:72.00 20.29:77.17))
dbCreateRect(cvid list("VIA12" "drawing") list(19.96:72.38 20.22:72.64))
dbCreateRect(cvid list("VIA12" "drawing") list(19.96:72.90 20.22:73.16))
dbCreateRect(cvid list("VIA12" "drawing") list(19.96:73.42 20.22:73.68))
dbCreateRect(cvid list("VIA12" "drawing") list(19.96:73.94 20.22:74.20))
dbCreateRect(cvid list("VIA12" "drawing") list(19.96:74.46 20.22:74.72))
dbCreateRect(cvid list("VIA12" "drawing") list(19.96:74.98 20.22:75.24))
dbCreateRect(cvid list("VIA12" "drawing") list(19.96:75.50 20.22:75.76))
dbCreateRect(cvid list("VIA12" "drawing") list(19.96:76.02 20.22:76.28))
dbCreateRect(cvid list("VIA12" "drawing") list(19.96:76.54 20.22:76.80))
dbCreateRect(cvid list("METAL2" "drawing") list(24.97:72.00 25.37:77.17))
dbCreateRect(cvid list("VIA12" "drawing") list(25.04:72.38 25.30:72.64))
dbCreateRect(cvid list("VIA12" "drawing") list(25.04:72.90 25.30:73.16))
dbCreateRect(cvid list("VIA12" "drawing") list(25.04:73.42 25.30:73.68))
dbCreateRect(cvid list("VIA12" "drawing") list(25.04:73.94 25.30:74.20))
dbCreateRect(cvid list("VIA12" "drawing") list(25.04:74.46 25.30:74.72))
dbCreateRect(cvid list("VIA12" "drawing") list(25.04:74.98 25.30:75.24))
dbCreateRect(cvid list("VIA12" "drawing") list(25.04:75.50 25.30:75.76))
dbCreateRect(cvid list("VIA12" "drawing") list(25.04:76.02 25.30:76.28))
dbCreateRect(cvid list("VIA12" "drawing") list(25.04:76.54 25.30:76.80))
dbCreateRect(cvid list("METAL2" "drawing") list(30.05:72.00 30.45:77.17))
dbCreateRect(cvid list("VIA12" "drawing") list(30.12:72.38 30.38:72.64))
dbCreateRect(cvid list("VIA12" "drawing") list(30.12:72.90 30.38:73.16))
dbCreateRect(cvid list("VIA12" "drawing") list(30.12:73.42 30.38:73.68))
dbCreateRect(cvid list("VIA12" "drawing") list(30.12:73.94 30.38:74.20))
dbCreateRect(cvid list("VIA12" "drawing") list(30.12:74.46 30.38:74.72))
dbCreateRect(cvid list("VIA12" "drawing") list(30.12:74.98 30.38:75.24))
dbCreateRect(cvid list("VIA12" "drawing") list(30.12:75.50 30.38:75.76))
dbCreateRect(cvid list("VIA12" "drawing") list(30.12:76.02 30.38:76.28))
dbCreateRect(cvid list("VIA12" "drawing") list(30.12:76.54 30.38:76.80))
dbCreateRect(cvid list("METAL2" "drawing") list(35.13:72.00 35.53:77.17))
dbCreateRect(cvid list("VIA12" "drawing") list(35.20:72.38 35.46:72.64))
dbCreateRect(cvid list("VIA12" "drawing") list(35.20:72.90 35.46:73.16))
dbCreateRect(cvid list("VIA12" "drawing") list(35.20:73.42 35.46:73.68))
dbCreateRect(cvid list("VIA12" "drawing") list(35.20:73.94 35.46:74.20))
dbCreateRect(cvid list("VIA12" "drawing") list(35.20:74.46 35.46:74.72))
dbCreateRect(cvid list("VIA12" "drawing") list(35.20:74.98 35.46:75.24))
dbCreateRect(cvid list("VIA12" "drawing") list(35.20:75.50 35.46:75.76))
dbCreateRect(cvid list("VIA12" "drawing") list(35.20:76.02 35.46:76.28))
dbCreateRect(cvid list("VIA12" "drawing") list(35.20:76.54 35.46:76.80))
dbCreateRect(cvid list("METAL2" "drawing") list(40.21:72.00 40.61:77.17))
dbCreateRect(cvid list("VIA12" "drawing") list(40.28:72.38 40.54:72.64))
dbCreateRect(cvid list("VIA12" "drawing") list(40.28:72.90 40.54:73.16))
dbCreateRect(cvid list("VIA12" "drawing") list(40.28:73.42 40.54:73.68))
dbCreateRect(cvid list("VIA12" "drawing") list(40.28:73.94 40.54:74.20))
dbCreateRect(cvid list("VIA12" "drawing") list(40.28:74.46 40.54:74.72))
dbCreateRect(cvid list("VIA12" "drawing") list(40.28:74.98 40.54:75.24))
dbCreateRect(cvid list("VIA12" "drawing") list(40.28:75.50 40.54:75.76))
dbCreateRect(cvid list("VIA12" "drawing") list(40.28:76.02 40.54:76.28))
dbCreateRect(cvid list("VIA12" "drawing") list(40.28:76.54 40.54:76.80))
dbCreateRect(cvid list("METAL2" "drawing") list(45.29:72.00 45.69:77.17))
dbCreateRect(cvid list("VIA12" "drawing") list(45.36:72.38 45.62:72.64))
dbCreateRect(cvid list("VIA12" "drawing") list(45.36:72.90 45.62:73.16))
dbCreateRect(cvid list("VIA12" "drawing") list(45.36:73.42 45.62:73.68))
dbCreateRect(cvid list("VIA12" "drawing") list(45.36:73.94 45.62:74.20))
dbCreateRect(cvid list("VIA12" "drawing") list(45.36:74.46 45.62:74.72))
dbCreateRect(cvid list("VIA12" "drawing") list(45.36:74.98 45.62:75.24))
dbCreateRect(cvid list("VIA12" "drawing") list(45.36:75.50 45.62:75.76))
dbCreateRect(cvid list("VIA12" "drawing") list(45.36:76.02 45.62:76.28))
dbCreateRect(cvid list("VIA12" "drawing") list(45.36:76.54 45.62:76.80))
dbCreateRect(cvid list("METAL2" "drawing") list(50.37:72.00 50.77:77.17))
dbCreateRect(cvid list("VIA12" "drawing") list(50.44:72.38 50.70:72.64))
dbCreateRect(cvid list("VIA12" "drawing") list(50.44:72.90 50.70:73.16))
dbCreateRect(cvid list("VIA12" "drawing") list(50.44:73.42 50.70:73.68))
dbCreateRect(cvid list("VIA12" "drawing") list(50.44:73.94 50.70:74.20))
dbCreateRect(cvid list("VIA12" "drawing") list(50.44:74.46 50.70:74.72))
dbCreateRect(cvid list("VIA12" "drawing") list(50.44:74.98 50.70:75.24))
dbCreateRect(cvid list("VIA12" "drawing") list(50.44:75.50 50.70:75.76))
dbCreateRect(cvid list("VIA12" "drawing") list(50.44:76.02 50.70:76.28))
dbCreateRect(cvid list("VIA12" "drawing") list(50.44:76.54 50.70:76.80))
dbCreateRect(cvid list("METAL2" "drawing") list(55.45:72.00 55.85:77.17))
dbCreateRect(cvid list("VIA12" "drawing") list(55.52:72.38 55.78:72.64))
dbCreateRect(cvid list("VIA12" "drawing") list(55.52:72.90 55.78:73.16))
dbCreateRect(cvid list("VIA12" "drawing") list(55.52:73.42 55.78:73.68))
dbCreateRect(cvid list("VIA12" "drawing") list(55.52:73.94 55.78:74.20))
dbCreateRect(cvid list("VIA12" "drawing") list(55.52:74.46 55.78:74.72))
dbCreateRect(cvid list("VIA12" "drawing") list(55.52:74.98 55.78:75.24))
dbCreateRect(cvid list("VIA12" "drawing") list(55.52:75.50 55.78:75.76))
dbCreateRect(cvid list("VIA12" "drawing") list(55.52:76.02 55.78:76.28))
dbCreateRect(cvid list("VIA12" "drawing") list(55.52:76.54 55.78:76.80))
dbCreateRect(cvid list("METAL2" "drawing") list(60.53:72.00 60.93:77.17))
dbCreateRect(cvid list("VIA12" "drawing") list(60.60:72.38 60.86:72.64))
dbCreateRect(cvid list("VIA12" "drawing") list(60.60:72.90 60.86:73.16))
dbCreateRect(cvid list("VIA12" "drawing") list(60.60:73.42 60.86:73.68))
dbCreateRect(cvid list("VIA12" "drawing") list(60.60:73.94 60.86:74.20))
dbCreateRect(cvid list("VIA12" "drawing") list(60.60:74.46 60.86:74.72))
dbCreateRect(cvid list("VIA12" "drawing") list(60.60:74.98 60.86:75.24))
dbCreateRect(cvid list("VIA12" "drawing") list(60.60:75.50 60.86:75.76))
dbCreateRect(cvid list("VIA12" "drawing") list(60.60:76.02 60.86:76.28))
dbCreateRect(cvid list("VIA12" "drawing") list(60.60:76.54 60.86:76.80))
dbCreateRect(cvid list("METAL2" "drawing") list(65.61:72.00 66.01:77.17))
dbCreateRect(cvid list("VIA12" "drawing") list(65.68:72.38 65.94:72.64))
dbCreateRect(cvid list("VIA12" "drawing") list(65.68:72.90 65.94:73.16))
dbCreateRect(cvid list("VIA12" "drawing") list(65.68:73.42 65.94:73.68))
dbCreateRect(cvid list("VIA12" "drawing") list(65.68:73.94 65.94:74.20))
dbCreateRect(cvid list("VIA12" "drawing") list(65.68:74.46 65.94:74.72))
dbCreateRect(cvid list("VIA12" "drawing") list(65.68:74.98 65.94:75.24))
dbCreateRect(cvid list("VIA12" "drawing") list(65.68:75.50 65.94:75.76))
dbCreateRect(cvid list("VIA12" "drawing") list(65.68:76.02 65.94:76.28))
dbCreateRect(cvid list("VIA12" "drawing") list(65.68:76.54 65.94:76.80))
dbCreateRect(cvid list("METAL2" "drawing") list(70.69:72.00 71.09:77.17))
dbCreateRect(cvid list("VIA12" "drawing") list(70.76:72.38 71.02:72.64))
dbCreateRect(cvid list("VIA12" "drawing") list(70.76:72.90 71.02:73.16))
dbCreateRect(cvid list("VIA12" "drawing") list(70.76:73.42 71.02:73.68))
dbCreateRect(cvid list("VIA12" "drawing") list(70.76:73.94 71.02:74.20))
dbCreateRect(cvid list("VIA12" "drawing") list(70.76:74.46 71.02:74.72))
dbCreateRect(cvid list("VIA12" "drawing") list(70.76:74.98 71.02:75.24))
dbCreateRect(cvid list("VIA12" "drawing") list(70.76:75.50 71.02:75.76))
dbCreateRect(cvid list("VIA12" "drawing") list(70.76:76.02 71.02:76.28))
dbCreateRect(cvid list("VIA12" "drawing") list(70.76:76.54 71.02:76.80))
dbCreateRect(cvid list("METAL2" "drawing") list(75.77:72.00 76.17:77.17))
dbCreateRect(cvid list("VIA12" "drawing") list(75.84:72.38 76.10:72.64))
dbCreateRect(cvid list("VIA12" "drawing") list(75.84:72.90 76.10:73.16))
dbCreateRect(cvid list("VIA12" "drawing") list(75.84:73.42 76.10:73.68))
dbCreateRect(cvid list("VIA12" "drawing") list(75.84:73.94 76.10:74.20))
dbCreateRect(cvid list("VIA12" "drawing") list(75.84:74.46 76.10:74.72))
dbCreateRect(cvid list("VIA12" "drawing") list(75.84:74.98 76.10:75.24))
dbCreateRect(cvid list("VIA12" "drawing") list(75.84:75.50 76.10:75.76))
dbCreateRect(cvid list("VIA12" "drawing") list(75.84:76.02 76.10:76.28))
dbCreateRect(cvid list("VIA12" "drawing") list(75.84:76.54 76.10:76.80))
dbCreateRect(cvid list("METAL2" "drawing") list(78.31:72.00 78.71:77.17))
dbCreateRect(cvid list("VIA12" "drawing") list(78.38:72.38 78.64:72.64))
dbCreateRect(cvid list("VIA12" "drawing") list(78.38:72.90 78.64:73.16))
dbCreateRect(cvid list("VIA12" "drawing") list(78.38:73.42 78.64:73.68))
dbCreateRect(cvid list("VIA12" "drawing") list(78.38:73.94 78.64:74.20))
dbCreateRect(cvid list("VIA12" "drawing") list(78.38:74.46 78.64:74.72))
dbCreateRect(cvid list("VIA12" "drawing") list(78.38:74.98 78.64:75.24))
dbCreateRect(cvid list("VIA12" "drawing") list(78.38:75.50 78.64:75.76))
dbCreateRect(cvid list("VIA12" "drawing") list(78.38:76.02 78.64:76.28))
dbCreateRect(cvid list("VIA12" "drawing") list(78.38:76.54 78.64:76.80))
dbCreateRect(cvid list("METAL1" "drawing") list(2.11:55.53 2.51:56.17))
dbCreateRect(cvid list("METAL1" "drawing") list(4.65:55.53 5.05:56.17))
dbCreateRect(cvid list("METAL1" "drawing") list(27.51:55.53 27.91:56.17))
dbCreateRect(cvid list("METAL1" "drawing") list(32.59:55.53 32.99:56.17))
dbCreateRect(cvid list("METAL1" "drawing") list(75.77:55.53 76.17:56.17))
dbCreateRect(cvid list("METAL1" "drawing") list(78.31:55.53 78.71:56.17))
dbCreateRect(cvid list("METAL2" "drawing") list(7.19:58.17 7.59:60.11))
dbCreateRect(cvid list("VIA12" "drawing") list(7.26:58.49 7.52:58.75))
dbCreateRect(cvid list("VIA12" "drawing") list(7.26:59.01 7.52:59.27))
dbCreateRect(cvid list("VIA12" "drawing") list(7.26:59.53 7.52:59.79))
dbCreateRect(cvid list("METAL2" "drawing") list(12.27:58.17 12.67:60.11))
dbCreateRect(cvid list("VIA12" "drawing") list(12.34:58.49 12.60:58.75))
dbCreateRect(cvid list("VIA12" "drawing") list(12.34:59.01 12.60:59.27))
dbCreateRect(cvid list("VIA12" "drawing") list(12.34:59.53 12.60:59.79))
dbCreateRect(cvid list("METAL2" "drawing") list(17.35:58.17 17.75:60.11))
dbCreateRect(cvid list("VIA12" "drawing") list(17.42:58.49 17.68:58.75))
dbCreateRect(cvid list("VIA12" "drawing") list(17.42:59.01 17.68:59.27))
dbCreateRect(cvid list("VIA12" "drawing") list(17.42:59.53 17.68:59.79))
dbCreateRect(cvid list("METAL2" "drawing") list(22.43:58.17 22.83:60.11))
dbCreateRect(cvid list("VIA12" "drawing") list(22.50:58.49 22.76:58.75))
dbCreateRect(cvid list("VIA12" "drawing") list(22.50:59.01 22.76:59.27))
dbCreateRect(cvid list("VIA12" "drawing") list(22.50:59.53 22.76:59.79))
dbCreateRect(cvid list("METAL2" "drawing") list(7.19:58.17 22.83:60.11))
dbCreateRect(cvid list("METAL2" "drawing") list(37.67:58.17 38.07:60.11))
dbCreateRect(cvid list("VIA12" "drawing") list(37.74:58.49 38.00:58.75))
dbCreateRect(cvid list("VIA12" "drawing") list(37.74:59.01 38.00:59.27))
dbCreateRect(cvid list("VIA12" "drawing") list(37.74:59.53 38.00:59.79))
dbCreateRect(cvid list("METAL2" "drawing") list(42.75:58.17 43.15:60.11))
dbCreateRect(cvid list("VIA12" "drawing") list(42.82:58.49 43.08:58.75))
dbCreateRect(cvid list("VIA12" "drawing") list(42.82:59.01 43.08:59.27))
dbCreateRect(cvid list("VIA12" "drawing") list(42.82:59.53 43.08:59.79))
dbCreateRect(cvid list("METAL2" "drawing") list(47.83:58.17 48.23:60.11))
dbCreateRect(cvid list("VIA12" "drawing") list(47.90:58.49 48.16:58.75))
dbCreateRect(cvid list("VIA12" "drawing") list(47.90:59.01 48.16:59.27))
dbCreateRect(cvid list("VIA12" "drawing") list(47.90:59.53 48.16:59.79))
dbCreateRect(cvid list("METAL2" "drawing") list(52.91:58.17 53.31:60.11))
dbCreateRect(cvid list("VIA12" "drawing") list(52.98:58.49 53.24:58.75))
dbCreateRect(cvid list("VIA12" "drawing") list(52.98:59.01 53.24:59.27))
dbCreateRect(cvid list("VIA12" "drawing") list(52.98:59.53 53.24:59.79))
dbCreateRect(cvid list("METAL2" "drawing") list(57.99:58.17 58.39:60.11))
dbCreateRect(cvid list("VIA12" "drawing") list(58.06:58.49 58.32:58.75))
dbCreateRect(cvid list("VIA12" "drawing") list(58.06:59.01 58.32:59.27))
dbCreateRect(cvid list("VIA12" "drawing") list(58.06:59.53 58.32:59.79))
dbCreateRect(cvid list("METAL2" "drawing") list(63.07:58.17 63.47:60.11))
dbCreateRect(cvid list("VIA12" "drawing") list(63.14:58.49 63.40:58.75))
dbCreateRect(cvid list("VIA12" "drawing") list(63.14:59.01 63.40:59.27))
dbCreateRect(cvid list("VIA12" "drawing") list(63.14:59.53 63.40:59.79))
dbCreateRect(cvid list("METAL2" "drawing") list(68.15:58.17 68.55:60.11))
dbCreateRect(cvid list("VIA12" "drawing") list(68.22:58.49 68.48:58.75))
dbCreateRect(cvid list("VIA12" "drawing") list(68.22:59.01 68.48:59.27))
dbCreateRect(cvid list("VIA12" "drawing") list(68.22:59.53 68.48:59.79))
dbCreateRect(cvid list("METAL2" "drawing") list(73.23:58.17 73.63:60.11))
dbCreateRect(cvid list("VIA12" "drawing") list(73.30:58.49 73.56:58.75))
dbCreateRect(cvid list("VIA12" "drawing") list(73.30:59.01 73.56:59.27))
dbCreateRect(cvid list("VIA12" "drawing") list(73.30:59.53 73.56:59.79))
dbCreateRect(cvid list("METAL2" "drawing") list(37.67:58.17 73.63:60.11))
dbCreateRect(cvid list("METAL1" "drawing") list(2.11:55.53 5.05:55.95))
dbCreateRect(cvid list("METAL1" "drawing") list(75.77:55.53 78.71:55.95))
dbCreateRect(cvid list("METAL1" "drawing") list(5.24:55.53 75.58:55.95))
dbCreateRect(cvid list("VIA12" "drawing") list(1.80:77.98 2.06:78.24))
dbCreateRect(cvid list("VIA12" "drawing") list(2.32:77.98 2.58:78.24))
dbCreateRect(cvid list("VIA12" "drawing") list(2.84:77.98 3.10:78.24))
dbCreateRect(cvid list("VIA12" "drawing") list(3.36:77.98 3.62:78.24))
dbCreateRect(cvid list("VIA12" "drawing") list(3.88:77.98 4.14:78.24))
dbCreateRect(cvid list("VIA12" "drawing") list(4.40:77.98 4.66:78.24))
dbCreateRect(cvid list("VIA12" "drawing") list(4.92:77.98 5.18:78.24))
dbCreateRect(cvid list("VIA12" "drawing") list(5.44:77.98 5.70:78.24))
dbCreateRect(cvid list("VIA12" "drawing") list(5.96:77.98 6.22:78.24))
dbCreateRect(cvid list("VIA12" "drawing") list(6.48:77.98 6.74:78.24))
dbCreateRect(cvid list("VIA12" "drawing") list(7.00:77.98 7.26:78.24))
dbCreateRect(cvid list("VIA12" "drawing") list(7.52:77.98 7.78:78.24))
dbCreateRect(cvid list("VIA12" "drawing") list(8.04:77.98 8.30:78.24))
dbCreateRect(cvid list("VIA12" "drawing") list(8.56:77.98 8.82:78.24))
dbCreateRect(cvid list("VIA12" "drawing") list(9.08:77.98 9.34:78.24))
dbCreateRect(cvid list("VIA12" "drawing") list(9.60:77.98 9.86:78.24))
dbCreateRect(cvid list("VIA12" "drawing") list(10.12:77.98 10.38:78.24))
dbCreateRect(cvid list("VIA12" "drawing") list(10.64:77.98 10.90:78.24))
dbCreateRect(cvid list("VIA12" "drawing") list(11.16:77.98 11.42:78.24))
dbCreateRect(cvid list("VIA12" "drawing") list(11.68:77.98 11.94:78.24))
dbCreateRect(cvid list("VIA12" "drawing") list(12.20:77.98 12.46:78.24))
dbCreateRect(cvid list("VIA12" "drawing") list(12.72:77.98 12.98:78.24))
dbCreateRect(cvid list("VIA12" "drawing") list(13.24:77.98 13.50:78.24))
dbCreateRect(cvid list("VIA12" "drawing") list(13.76:77.98 14.02:78.24))
dbCreateRect(cvid list("VIA12" "drawing") list(14.28:77.98 14.54:78.24))
dbCreateRect(cvid list("VIA12" "drawing") list(14.80:77.98 15.06:78.24))
dbCreateRect(cvid list("VIA12" "drawing") list(15.32:77.98 15.58:78.24))
dbCreateRect(cvid list("VIA12" "drawing") list(15.84:77.98 16.10:78.24))
dbCreateRect(cvid list("VIA12" "drawing") list(16.36:77.98 16.62:78.24))
dbCreateRect(cvid list("VIA12" "drawing") list(16.88:77.98 17.14:78.24))
dbCreateRect(cvid list("VIA12" "drawing") list(17.40:77.98 17.66:78.24))
dbCreateRect(cvid list("VIA12" "drawing") list(17.92:77.98 18.18:78.24))
dbCreateRect(cvid list("VIA12" "drawing") list(18.44:77.98 18.70:78.24))
dbCreateRect(cvid list("VIA12" "drawing") list(18.96:77.98 19.22:78.24))
dbCreateRect(cvid list("VIA12" "drawing") list(19.48:77.98 19.74:78.24))
dbCreateRect(cvid list("VIA12" "drawing") list(20.00:77.98 20.26:78.24))
dbCreateRect(cvid list("VIA12" "drawing") list(20.52:77.98 20.78:78.24))
dbCreateRect(cvid list("VIA12" "drawing") list(21.04:77.98 21.30:78.24))
dbCreateRect(cvid list("VIA12" "drawing") list(21.56:77.98 21.82:78.24))
dbCreateRect(cvid list("VIA12" "drawing") list(22.08:77.98 22.34:78.24))
dbCreateRect(cvid list("VIA12" "drawing") list(22.60:77.98 22.86:78.24))
dbCreateRect(cvid list("VIA12" "drawing") list(23.12:77.98 23.38:78.24))
dbCreateRect(cvid list("VIA12" "drawing") list(23.64:77.98 23.90:78.24))
dbCreateRect(cvid list("VIA12" "drawing") list(24.16:77.98 24.42:78.24))
dbCreateRect(cvid list("VIA12" "drawing") list(24.68:77.98 24.94:78.24))
dbCreateRect(cvid list("VIA12" "drawing") list(25.20:77.98 25.46:78.24))
dbCreateRect(cvid list("VIA12" "drawing") list(25.72:77.98 25.98:78.24))
dbCreateRect(cvid list("VIA12" "drawing") list(26.24:77.98 26.50:78.24))
dbCreateRect(cvid list("VIA12" "drawing") list(26.76:77.98 27.02:78.24))
dbCreateRect(cvid list("VIA12" "drawing") list(27.28:77.98 27.54:78.24))
dbCreateRect(cvid list("VIA12" "drawing") list(27.80:77.98 28.06:78.24))
dbCreateRect(cvid list("VIA12" "drawing") list(28.32:77.98 28.58:78.24))
dbCreateRect(cvid list("VIA12" "drawing") list(28.84:77.98 29.10:78.24))
dbCreateRect(cvid list("VIA12" "drawing") list(29.36:77.98 29.62:78.24))
dbCreateRect(cvid list("VIA12" "drawing") list(29.88:77.98 30.14:78.24))
dbCreateRect(cvid list("VIA12" "drawing") list(30.40:77.98 30.66:78.24))
dbCreateRect(cvid list("VIA12" "drawing") list(30.92:77.98 31.18:78.24))
dbCreateRect(cvid list("VIA12" "drawing") list(31.44:77.98 31.70:78.24))
dbCreateRect(cvid list("VIA12" "drawing") list(31.96:77.98 32.22:78.24))
dbCreateRect(cvid list("VIA12" "drawing") list(32.48:77.98 32.74:78.24))
dbCreateRect(cvid list("VIA12" "drawing") list(33.00:77.98 33.26:78.24))
dbCreateRect(cvid list("VIA12" "drawing") list(33.52:77.98 33.78:78.24))
dbCreateRect(cvid list("VIA12" "drawing") list(34.04:77.98 34.30:78.24))
dbCreateRect(cvid list("VIA12" "drawing") list(34.56:77.98 34.82:78.24))
dbCreateRect(cvid list("VIA12" "drawing") list(35.08:77.98 35.34:78.24))
dbCreateRect(cvid list("VIA12" "drawing") list(35.60:77.98 35.86:78.24))
dbCreateRect(cvid list("VIA12" "drawing") list(36.12:77.98 36.38:78.24))
dbCreateRect(cvid list("VIA12" "drawing") list(36.64:77.98 36.90:78.24))
dbCreateRect(cvid list("VIA12" "drawing") list(37.16:77.98 37.42:78.24))
dbCreateRect(cvid list("VIA12" "drawing") list(37.68:77.98 37.94:78.24))
dbCreateRect(cvid list("VIA12" "drawing") list(38.20:77.98 38.46:78.24))
dbCreateRect(cvid list("VIA12" "drawing") list(38.72:77.98 38.98:78.24))
dbCreateRect(cvid list("VIA12" "drawing") list(39.24:77.98 39.50:78.24))
dbCreateRect(cvid list("VIA12" "drawing") list(39.76:77.98 40.02:78.24))
dbCreateRect(cvid list("VIA12" "drawing") list(40.28:77.98 40.54:78.24))
dbCreateRect(cvid list("VIA12" "drawing") list(40.80:77.98 41.06:78.24))
dbCreateRect(cvid list("VIA12" "drawing") list(41.32:77.98 41.58:78.24))
dbCreateRect(cvid list("VIA12" "drawing") list(41.84:77.98 42.10:78.24))
dbCreateRect(cvid list("VIA12" "drawing") list(42.36:77.98 42.62:78.24))
dbCreateRect(cvid list("VIA12" "drawing") list(42.88:77.98 43.14:78.24))
dbCreateRect(cvid list("VIA12" "drawing") list(43.40:77.98 43.66:78.24))
dbCreateRect(cvid list("VIA12" "drawing") list(43.92:77.98 44.18:78.24))
dbCreateRect(cvid list("VIA12" "drawing") list(44.44:77.98 44.70:78.24))
dbCreateRect(cvid list("VIA12" "drawing") list(44.96:77.98 45.22:78.24))
dbCreateRect(cvid list("VIA12" "drawing") list(45.48:77.98 45.74:78.24))
dbCreateRect(cvid list("VIA12" "drawing") list(46.00:77.98 46.26:78.24))
dbCreateRect(cvid list("VIA12" "drawing") list(46.52:77.98 46.78:78.24))
dbCreateRect(cvid list("VIA12" "drawing") list(47.04:77.98 47.30:78.24))
dbCreateRect(cvid list("VIA12" "drawing") list(47.56:77.98 47.82:78.24))
dbCreateRect(cvid list("VIA12" "drawing") list(48.08:77.98 48.34:78.24))
dbCreateRect(cvid list("VIA12" "drawing") list(48.60:77.98 48.86:78.24))
dbCreateRect(cvid list("VIA12" "drawing") list(49.12:77.98 49.38:78.24))
dbCreateRect(cvid list("VIA12" "drawing") list(49.64:77.98 49.90:78.24))
dbCreateRect(cvid list("VIA12" "drawing") list(50.16:77.98 50.42:78.24))
dbCreateRect(cvid list("VIA12" "drawing") list(50.68:77.98 50.94:78.24))
dbCreateRect(cvid list("VIA12" "drawing") list(51.20:77.98 51.46:78.24))
dbCreateRect(cvid list("VIA12" "drawing") list(51.72:77.98 51.98:78.24))
dbCreateRect(cvid list("VIA12" "drawing") list(52.24:77.98 52.50:78.24))
dbCreateRect(cvid list("VIA12" "drawing") list(52.76:77.98 53.02:78.24))
dbCreateRect(cvid list("VIA12" "drawing") list(53.28:77.98 53.54:78.24))
dbCreateRect(cvid list("VIA12" "drawing") list(53.80:77.98 54.06:78.24))
dbCreateRect(cvid list("VIA12" "drawing") list(54.32:77.98 54.58:78.24))
dbCreateRect(cvid list("VIA12" "drawing") list(54.84:77.98 55.10:78.24))
dbCreateRect(cvid list("VIA12" "drawing") list(55.36:77.98 55.62:78.24))
dbCreateRect(cvid list("VIA12" "drawing") list(55.88:77.98 56.14:78.24))
dbCreateRect(cvid list("VIA12" "drawing") list(56.40:77.98 56.66:78.24))
dbCreateRect(cvid list("VIA12" "drawing") list(56.92:77.98 57.18:78.24))
dbCreateRect(cvid list("VIA12" "drawing") list(57.44:77.98 57.70:78.24))
dbCreateRect(cvid list("VIA12" "drawing") list(57.96:77.98 58.22:78.24))
dbCreateRect(cvid list("VIA12" "drawing") list(58.48:77.98 58.74:78.24))
dbCreateRect(cvid list("VIA12" "drawing") list(59.00:77.98 59.26:78.24))
dbCreateRect(cvid list("VIA12" "drawing") list(59.52:77.98 59.78:78.24))
dbCreateRect(cvid list("VIA12" "drawing") list(60.04:77.98 60.30:78.24))
dbCreateRect(cvid list("VIA12" "drawing") list(60.56:77.98 60.82:78.24))
dbCreateRect(cvid list("VIA12" "drawing") list(61.08:77.98 61.34:78.24))
dbCreateRect(cvid list("VIA12" "drawing") list(61.60:77.98 61.86:78.24))
dbCreateRect(cvid list("VIA12" "drawing") list(62.12:77.98 62.38:78.24))
dbCreateRect(cvid list("VIA12" "drawing") list(62.64:77.98 62.90:78.24))
dbCreateRect(cvid list("VIA12" "drawing") list(63.16:77.98 63.42:78.24))
dbCreateRect(cvid list("VIA12" "drawing") list(63.68:77.98 63.94:78.24))
dbCreateRect(cvid list("VIA12" "drawing") list(64.20:77.98 64.46:78.24))
dbCreateRect(cvid list("VIA12" "drawing") list(64.72:77.98 64.98:78.24))
dbCreateRect(cvid list("VIA12" "drawing") list(65.24:77.98 65.50:78.24))
dbCreateRect(cvid list("VIA12" "drawing") list(65.76:77.98 66.02:78.24))
dbCreateRect(cvid list("VIA12" "drawing") list(66.28:77.98 66.54:78.24))
dbCreateRect(cvid list("VIA12" "drawing") list(66.80:77.98 67.06:78.24))
dbCreateRect(cvid list("VIA12" "drawing") list(67.32:77.98 67.58:78.24))
dbCreateRect(cvid list("VIA12" "drawing") list(67.84:77.98 68.10:78.24))
dbCreateRect(cvid list("VIA12" "drawing") list(68.36:77.98 68.62:78.24))
dbCreateRect(cvid list("VIA12" "drawing") list(68.88:77.98 69.14:78.24))
dbCreateRect(cvid list("VIA12" "drawing") list(69.40:77.98 69.66:78.24))
dbCreateRect(cvid list("VIA12" "drawing") list(69.92:77.98 70.18:78.24))
dbCreateRect(cvid list("VIA12" "drawing") list(70.44:77.98 70.70:78.24))
dbCreateRect(cvid list("VIA12" "drawing") list(70.96:77.98 71.22:78.24))
dbCreateRect(cvid list("VIA12" "drawing") list(71.48:77.98 71.74:78.24))
dbCreateRect(cvid list("VIA12" "drawing") list(72.00:77.98 72.26:78.24))
dbCreateRect(cvid list("VIA12" "drawing") list(72.52:77.98 72.78:78.24))
dbCreateRect(cvid list("VIA12" "drawing") list(73.04:77.98 73.30:78.24))
dbCreateRect(cvid list("VIA12" "drawing") list(73.56:77.98 73.82:78.24))
dbCreateRect(cvid list("VIA12" "drawing") list(74.08:77.98 74.34:78.24))
dbCreateRect(cvid list("VIA12" "drawing") list(74.60:77.98 74.86:78.24))
dbCreateRect(cvid list("VIA12" "drawing") list(75.12:77.98 75.38:78.24))
dbCreateRect(cvid list("VIA12" "drawing") list(75.64:77.98 75.90:78.24))
dbCreateRect(cvid list("VIA12" "drawing") list(76.16:77.98 76.42:78.24))
dbCreateRect(cvid list("VIA12" "drawing") list(76.68:77.98 76.94:78.24))
dbCreateRect(cvid list("VIA12" "drawing") list(77.20:77.98 77.46:78.24))
dbCreateRect(cvid list("VIA12" "drawing") list(77.72:77.98 77.98:78.24))
dbCreateRect(cvid list("VIA12" "drawing") list(78.24:77.98 78.50:78.24))
dbCreateRect(cvid list("VIA12" "drawing") list(78.76:77.98 79.02:78.24))
dbCreateRect(cvid list("METAL2" "drawing") list(2.11:47.42 18.93:49.36))
dbCreateRect(cvid list("METAL2" "drawing") list(2.11:7.22 18.93:9.16))
dbCreateRect(cvid list("VIA12" "drawing") list(2.18:47.74 2.44:48.00))
dbCreateRect(cvid list("VIA12" "drawing") list(2.18:48.26 2.44:48.52))
dbCreateRect(cvid list("VIA12" "drawing") list(2.18:48.78 2.44:49.04))
dbCreateRect(cvid list("VIA12" "drawing") list(2.18:7.54 2.44:7.80))
dbCreateRect(cvid list("VIA12" "drawing") list(2.18:8.06 2.44:8.32))
dbCreateRect(cvid list("VIA12" "drawing") list(2.18:8.58 2.44:8.84))
dbCreateRect(cvid list("VIA12" "drawing") list(7.26:47.74 7.52:48.00))
dbCreateRect(cvid list("VIA12" "drawing") list(7.26:48.26 7.52:48.52))
dbCreateRect(cvid list("VIA12" "drawing") list(7.26:48.78 7.52:49.04))
dbCreateRect(cvid list("VIA12" "drawing") list(7.26:7.54 7.52:7.80))
dbCreateRect(cvid list("VIA12" "drawing") list(7.26:8.06 7.52:8.32))
dbCreateRect(cvid list("VIA12" "drawing") list(7.26:8.58 7.52:8.84))
dbCreateRect(cvid list("VIA12" "drawing") list(12.34:47.74 12.60:48.00))
dbCreateRect(cvid list("VIA12" "drawing") list(12.34:48.26 12.60:48.52))
dbCreateRect(cvid list("VIA12" "drawing") list(12.34:48.78 12.60:49.04))
dbCreateRect(cvid list("VIA12" "drawing") list(12.34:7.54 12.60:7.80))
dbCreateRect(cvid list("VIA12" "drawing") list(12.34:8.06 12.60:8.32))
dbCreateRect(cvid list("VIA12" "drawing") list(12.34:8.58 12.60:8.84))
dbCreateRect(cvid list("VIA12" "drawing") list(17.42:47.74 17.68:48.00))
dbCreateRect(cvid list("VIA12" "drawing") list(17.42:48.26 17.68:48.52))
dbCreateRect(cvid list("VIA12" "drawing") list(17.42:48.78 17.68:49.04))
dbCreateRect(cvid list("VIA12" "drawing") list(17.42:7.54 17.68:7.80))
dbCreateRect(cvid list("VIA12" "drawing") list(17.42:8.06 17.68:8.32))
dbCreateRect(cvid list("VIA12" "drawing") list(17.42:8.58 17.68:8.84))
dbCreateRect(cvid list("METAL2" "drawing") list(4.65:43.48 18.93:45.42))
dbCreateRect(cvid list("METAL2" "drawing") list(4.65:11.16 18.93:13.10))
dbCreateRect(cvid list("VIA12" "drawing") list(4.72:43.80 4.98:44.06))
dbCreateRect(cvid list("VIA12" "drawing") list(4.72:44.32 4.98:44.58))
dbCreateRect(cvid list("VIA12" "drawing") list(4.72:44.84 4.98:45.10))
dbCreateRect(cvid list("VIA12" "drawing") list(4.72:11.48 4.98:11.74))
dbCreateRect(cvid list("VIA12" "drawing") list(4.72:12.00 4.98:12.26))
dbCreateRect(cvid list("VIA12" "drawing") list(4.72:12.52 4.98:12.78))
dbCreateRect(cvid list("VIA12" "drawing") list(14.88:43.80 15.14:44.06))
dbCreateRect(cvid list("VIA12" "drawing") list(14.88:44.32 15.14:44.58))
dbCreateRect(cvid list("VIA12" "drawing") list(14.88:44.84 15.14:45.10))
dbCreateRect(cvid list("VIA12" "drawing") list(14.88:11.48 15.14:11.74))
dbCreateRect(cvid list("VIA12" "drawing") list(14.88:12.00 15.14:12.26))
dbCreateRect(cvid list("VIA12" "drawing") list(14.88:12.52 15.14:12.78))
dbCreateRect(cvid list("METAL2" "drawing") list(9.73:39.54 18.93:41.48))
dbCreateRect(cvid list("METAL2" "drawing") list(9.73:15.10 18.93:17.04))
dbCreateRect(cvid list("VIA12" "drawing") list(9.80:39.86 10.06:40.12))
dbCreateRect(cvid list("VIA12" "drawing") list(9.80:40.38 10.06:40.64))
dbCreateRect(cvid list("VIA12" "drawing") list(9.80:40.90 10.06:41.16))
dbCreateRect(cvid list("VIA12" "drawing") list(9.80:15.42 10.06:15.68))
dbCreateRect(cvid list("VIA12" "drawing") list(9.80:15.94 10.06:16.20))
dbCreateRect(cvid list("VIA12" "drawing") list(9.80:16.46 10.06:16.72))
dbCreatePolygon(cvid list("METAL1" "drawing") list(2.11:29.36 2.51:29.36 2.51:29.14 4.45:29.14 4.45:28.72 2.11:28.72 2.11:29.36))
dbCreatePolygon(cvid list("METAL1" "drawing") list(2.11:27.22 2.51:27.22 2.51:27.44 4.45:27.44 4.45:27.86 2.11:27.86 2.11:27.22))
dbCreatePolygon(cvid list("METAL1" "drawing") list(17.75:29.36 17.35:29.36 17.35:29.14 15.41:29.14 15.41:28.72 17.75:28.72 17.75:29.36))
dbCreatePolygon(cvid list("METAL1" "drawing") list(17.75:27.22 17.35:27.22 17.35:27.44 15.41:27.44 15.41:27.86 17.75:27.86 17.75:27.22))
dbCreateRect(cvid list("VIA12" "drawing") list(5.47:28.80 5.73:29.06))
dbCreateRect(cvid list("VIA12" "drawing") list(5.99:28.80 6.25:29.06))
dbCreateRect(cvid list("VIA12" "drawing") list(6.51:28.80 6.77:29.06))
dbCreateRect(cvid list("VIA12" "drawing") list(5.47:27.52 5.73:27.78))
dbCreateRect(cvid list("VIA12" "drawing") list(5.99:27.52 6.25:27.78))
dbCreateRect(cvid list("VIA12" "drawing") list(6.51:27.52 6.77:27.78))
dbCreateRect(cvid list("VIA12" "drawing") list(8.01:28.80 8.27:29.06))
dbCreateRect(cvid list("VIA12" "drawing") list(8.53:28.80 8.79:29.06))
dbCreateRect(cvid list("VIA12" "drawing") list(9.05:28.80 9.31:29.06))
dbCreateRect(cvid list("VIA12" "drawing") list(8.01:27.52 8.27:27.78))
dbCreateRect(cvid list("VIA12" "drawing") list(8.53:27.52 8.79:27.78))
dbCreateRect(cvid list("VIA12" "drawing") list(9.05:27.52 9.31:27.78))
dbCreateRect(cvid list("VIA12" "drawing") list(10.55:28.80 10.81:29.06))
dbCreateRect(cvid list("VIA12" "drawing") list(11.07:28.80 11.33:29.06))
dbCreateRect(cvid list("VIA12" "drawing") list(11.59:28.80 11.85:29.06))
dbCreateRect(cvid list("VIA12" "drawing") list(10.55:27.52 10.81:27.78))
dbCreateRect(cvid list("VIA12" "drawing") list(11.07:27.52 11.33:27.78))
dbCreateRect(cvid list("VIA12" "drawing") list(11.59:27.52 11.85:27.78))
dbCreateRect(cvid list("VIA12" "drawing") list(13.09:28.80 13.35:29.06))
dbCreateRect(cvid list("VIA12" "drawing") list(13.61:28.80 13.87:29.06))
dbCreateRect(cvid list("VIA12" "drawing") list(14.13:28.80 14.39:29.06))
dbCreateRect(cvid list("VIA12" "drawing") list(13.09:27.52 13.35:27.78))
dbCreateRect(cvid list("VIA12" "drawing") list(13.61:27.52 13.87:27.78))
dbCreateRect(cvid list("VIA12" "drawing") list(14.13:27.52 14.39:27.78))
dbCreateRect(cvid list("METAL2" "drawing") list(2.70:28.72 6.99:29.14))
dbCreateRect(cvid list("METAL2" "drawing") list(7.78:28.72 12.07:29.14))
dbCreateRect(cvid list("METAL2" "drawing") list(2.70:27.44 6.99:27.86))
dbCreateRect(cvid list("METAL2" "drawing") list(7.78:27.44 12.07:27.86))
dbCreateRect(cvid list("METAL2" "drawing") list(12.86:28.72 14.61:29.14))
dbCreateRect(cvid list("METAL2" "drawing") list(12.86:27.44 14.61:27.86))
dbCreatePolygon(cvid list("METAL2" "drawing") list(6.09:29.14 6.99:29.14 8.69:27.44 7.79:27.44 6.09:29.14))
dbCreatePolygon(cvid list("METAL1" "drawing") list(7.79:29.14 8.69:29.14 6.99:27.44 6.09:27.44 7.79:29.14))
dbCreatePolygon(cvid list("METAL2" "drawing") list(11.17:29.14 12.07:29.14 13.77:27.44 12.87:27.44 11.17:29.14))
dbCreatePolygon(cvid list("METAL1" "drawing") list(12.87:29.14 13.77:29.14 12.07:27.44 11.17:27.44 12.87:29.14))
dbCreateRect(cvid list("VIA12" "drawing") list(83.84:78.48 84.10:78.74))
dbCreateRect(cvid list("VIA12" "drawing") list(84.36:78.48 84.62:78.74))
dbCreateRect(cvid list("VIA12" "drawing") list(84.88:78.48 85.14:78.74))
dbCreateRect(cvid list("VIA12" "drawing") list(85.40:78.48 85.66:78.74))
dbCreateRect(cvid list("VIA12" "drawing") list(85.92:78.48 86.18:78.74))
dbCreateRect(cvid list("VIA12" "drawing") list(86.44:78.48 86.70:78.74))
dbCreateRect(cvid list("VIA12" "drawing") list(86.96:78.48 87.22:78.74))
dbCreateRect(cvid list("VIA12" "drawing") list(87.48:78.48 87.74:78.74))
dbCreateRect(cvid list("VIA12" "drawing") list(88.00:78.48 88.26:78.74))
dbCreateRect(cvid list("VIA12" "drawing") list(88.52:78.48 88.78:78.74))
dbCreateRect(cvid list("VIA12" "drawing") list(89.04:78.48 89.30:78.74))
dbCreateRect(cvid list("VIA12" "drawing") list(89.56:78.48 89.82:78.74))
dbCreateRect(cvid list("VIA12" "drawing") list(90.08:78.48 90.34:78.74))
dbCreateRect(cvid list("VIA12" "drawing") list(90.60:78.48 90.86:78.74))
dbCreateRect(cvid list("VIA12" "drawing") list(91.12:78.48 91.38:78.74))
dbCreateRect(cvid list("VIA12" "drawing") list(91.64:78.48 91.90:78.74))
dbCreateRect(cvid list("VIA12" "drawing") list(92.16:78.48 92.42:78.74))
dbCreateRect(cvid list("VIA12" "drawing") list(92.68:78.48 92.94:78.74))
dbCreateRect(cvid list("VIA12" "drawing") list(93.20:78.48 93.46:78.74))
dbCreateRect(cvid list("METAL2" "drawing") list(83.83:72.00 84.23:77.67))
dbCreateRect(cvid list("VIA12" "drawing") list(83.90:72.11 84.16:72.37))
dbCreateRect(cvid list("VIA12" "drawing") list(83.90:72.63 84.16:72.89))
dbCreateRect(cvid list("VIA12" "drawing") list(83.90:73.15 84.16:73.41))
dbCreateRect(cvid list("VIA12" "drawing") list(83.90:73.67 84.16:73.93))
dbCreateRect(cvid list("VIA12" "drawing") list(83.90:74.19 84.16:74.45))
dbCreateRect(cvid list("VIA12" "drawing") list(83.90:74.71 84.16:74.97))
dbCreateRect(cvid list("VIA12" "drawing") list(83.90:75.23 84.16:75.49))
dbCreateRect(cvid list("VIA12" "drawing") list(83.90:75.75 84.16:76.01))
dbCreateRect(cvid list("VIA12" "drawing") list(83.90:76.27 84.16:76.53))
dbCreateRect(cvid list("VIA12" "drawing") list(83.90:76.79 84.16:77.05))
dbCreateRect(cvid list("VIA12" "drawing") list(83.90:77.31 84.16:77.57))
dbCreateRect(cvid list("METAL2" "drawing") list(85.37:72.00 85.77:77.67))
dbCreateRect(cvid list("VIA12" "drawing") list(85.44:72.11 85.70:72.37))
dbCreateRect(cvid list("VIA12" "drawing") list(85.44:72.63 85.70:72.89))
dbCreateRect(cvid list("VIA12" "drawing") list(85.44:73.15 85.70:73.41))
dbCreateRect(cvid list("VIA12" "drawing") list(85.44:73.67 85.70:73.93))
dbCreateRect(cvid list("VIA12" "drawing") list(85.44:74.19 85.70:74.45))
dbCreateRect(cvid list("VIA12" "drawing") list(85.44:74.71 85.70:74.97))
dbCreateRect(cvid list("VIA12" "drawing") list(85.44:75.23 85.70:75.49))
dbCreateRect(cvid list("VIA12" "drawing") list(85.44:75.75 85.70:76.01))
dbCreateRect(cvid list("VIA12" "drawing") list(85.44:76.27 85.70:76.53))
dbCreateRect(cvid list("VIA12" "drawing") list(85.44:76.79 85.70:77.05))
dbCreateRect(cvid list("VIA12" "drawing") list(85.44:77.31 85.70:77.57))
dbCreateRect(cvid list("METAL2" "drawing") list(88.45:72.00 88.85:77.67))
dbCreateRect(cvid list("VIA12" "drawing") list(88.52:72.11 88.78:72.37))
dbCreateRect(cvid list("VIA12" "drawing") list(88.52:72.63 88.78:72.89))
dbCreateRect(cvid list("VIA12" "drawing") list(88.52:73.15 88.78:73.41))
dbCreateRect(cvid list("VIA12" "drawing") list(88.52:73.67 88.78:73.93))
dbCreateRect(cvid list("VIA12" "drawing") list(88.52:74.19 88.78:74.45))
dbCreateRect(cvid list("VIA12" "drawing") list(88.52:74.71 88.78:74.97))
dbCreateRect(cvid list("VIA12" "drawing") list(88.52:75.23 88.78:75.49))
dbCreateRect(cvid list("VIA12" "drawing") list(88.52:75.75 88.78:76.01))
dbCreateRect(cvid list("VIA12" "drawing") list(88.52:76.27 88.78:76.53))
dbCreateRect(cvid list("VIA12" "drawing") list(88.52:76.79 88.78:77.05))
dbCreateRect(cvid list("VIA12" "drawing") list(88.52:77.31 88.78:77.57))
dbCreateRect(cvid list("METAL2" "drawing") list(91.53:72.00 91.93:77.67))
dbCreateRect(cvid list("VIA12" "drawing") list(91.60:72.11 91.86:72.37))
dbCreateRect(cvid list("VIA12" "drawing") list(91.60:72.63 91.86:72.89))
dbCreateRect(cvid list("VIA12" "drawing") list(91.60:73.15 91.86:73.41))
dbCreateRect(cvid list("VIA12" "drawing") list(91.60:73.67 91.86:73.93))
dbCreateRect(cvid list("VIA12" "drawing") list(91.60:74.19 91.86:74.45))
dbCreateRect(cvid list("VIA12" "drawing") list(91.60:74.71 91.86:74.97))
dbCreateRect(cvid list("VIA12" "drawing") list(91.60:75.23 91.86:75.49))
dbCreateRect(cvid list("VIA12" "drawing") list(91.60:75.75 91.86:76.01))
dbCreateRect(cvid list("VIA12" "drawing") list(91.60:76.27 91.86:76.53))
dbCreateRect(cvid list("VIA12" "drawing") list(91.60:76.79 91.86:77.05))
dbCreateRect(cvid list("VIA12" "drawing") list(91.60:77.31 91.86:77.57))
dbCreateRect(cvid list("METAL2" "drawing") list(93.07:72.00 93.47:77.67))
dbCreateRect(cvid list("VIA12" "drawing") list(93.14:72.11 93.40:72.37))
dbCreateRect(cvid list("VIA12" "drawing") list(93.14:72.63 93.40:72.89))
dbCreateRect(cvid list("VIA12" "drawing") list(93.14:73.15 93.40:73.41))
dbCreateRect(cvid list("VIA12" "drawing") list(93.14:73.67 93.40:73.93))
dbCreateRect(cvid list("VIA12" "drawing") list(93.14:74.19 93.40:74.45))
dbCreateRect(cvid list("VIA12" "drawing") list(93.14:74.71 93.40:74.97))
dbCreateRect(cvid list("VIA12" "drawing") list(93.14:75.23 93.40:75.49))
dbCreateRect(cvid list("VIA12" "drawing") list(93.14:75.75 93.40:76.01))
dbCreateRect(cvid list("VIA12" "drawing") list(93.14:76.27 93.40:76.53))
dbCreateRect(cvid list("VIA12" "drawing") list(93.14:76.79 93.40:77.05))
dbCreateRect(cvid list("VIA12" "drawing") list(93.14:77.31 93.40:77.57))
dbCreateRect(cvid list("METAL1" "drawing") list(83.83:65.41 84.23:67.67))
dbCreateRect(cvid list("METAL1" "drawing") list(85.37:65.41 85.77:67.67))
dbCreateRect(cvid list("METAL1" "drawing") list(89.99:65.41 90.39:67.67))
dbCreateRect(cvid list("METAL1" "drawing") list(91.53:65.41 91.93:67.67))
dbCreateRect(cvid list("METAL1" "drawing") list(93.07:65.41 93.47:67.67))
dbCreateRect(cvid list("METAL1" "drawing") list(83.83:67.03 85.77:67.45))
dbCreateRect(cvid list("METAL1" "drawing") list(83.83:65.63 85.77:66.05))
dbCreateRect(cvid list("METAL1" "drawing") list(91.53:67.03 93.47:67.45))
dbCreateRect(cvid list("METAL1" "drawing") list(91.53:65.63 93.47:66.05))
dbCreateRect(cvid list("METAL1" "drawing") list(85.96:67.03 91.33:67.45))
dbCreateRect(cvid list("METAL1" "drawing") list(85.96:65.63 91.33:66.05))
dbCreateRect(cvid list("VIA12" "drawing") list(86.98:67.77 87.24:68.03))
dbCreateRect(cvid list("VIA12" "drawing") list(86.98:68.29 87.24:68.55))
dbCreateRect(cvid list("VIA12" "drawing") list(86.98:68.81 87.24:69.07))
dbCreateRect(cvid list("VIA12" "drawing") list(86.98:64.01 87.24:64.27))
dbCreateRect(cvid list("VIA12" "drawing") list(86.98:64.53 87.24:64.79))
dbCreateRect(cvid list("VIA12" "drawing") list(86.98:65.05 87.24:65.31))
dbCreateRect(cvid list("METAL2" "drawing") list(86.91:63.91 87.31:69.17))
dbCreateRect(cvid list("VIA12" "drawing") list(88.52:67.77 88.78:68.03))
dbCreateRect(cvid list("VIA12" "drawing") list(88.52:68.29 88.78:68.55))
dbCreateRect(cvid list("VIA12" "drawing") list(88.52:68.81 88.78:69.07))
dbCreateRect(cvid list("VIA12" "drawing") list(88.52:64.01 88.78:64.27))
dbCreateRect(cvid list("VIA12" "drawing") list(88.52:64.53 88.78:64.79))
dbCreateRect(cvid list("VIA12" "drawing") list(88.52:65.05 88.78:65.31))
dbCreateRect(cvid list("METAL2" "drawing") list(88.45:63.91 88.85:69.17))
dbCreateRect(cvid list("METAL2" "drawing") list(86.91:55.41 87.31:56.91))
dbCreateRect(cvid list("VIA12" "drawing") list(86.98:55.51 87.24:55.77))
dbCreateRect(cvid list("VIA12" "drawing") list(86.98:56.03 87.24:56.29))
dbCreateRect(cvid list("VIA12" "drawing") list(86.98:56.55 87.24:56.81))
dbCreateRect(cvid list("VIA23" "drawing") list(86.98:55.51 87.24:55.77))
dbCreateRect(cvid list("VIA23" "drawing") list(86.98:56.03 87.24:56.29))
dbCreateRect(cvid list("VIA23" "drawing") list(86.98:56.55 87.24:56.81))
dbCreateRect(cvid list("METAL3" "drawing") list(86.91:54.24 87.31:56.91))
dbCreateRect(cvid list("METAL2" "drawing") list(89.99:55.41 90.39:56.91))
dbCreateRect(cvid list("VIA12" "drawing") list(90.06:55.51 90.32:55.77))
dbCreateRect(cvid list("VIA12" "drawing") list(90.06:56.03 90.32:56.29))
dbCreateRect(cvid list("VIA12" "drawing") list(90.06:56.55 90.32:56.81))
dbCreateRect(cvid list("VIA23" "drawing") list(90.06:55.51 90.32:55.77))
dbCreateRect(cvid list("VIA23" "drawing") list(90.06:56.03 90.32:56.29))
dbCreateRect(cvid list("VIA23" "drawing") list(90.06:56.55 90.32:56.81))
dbCreateRect(cvid list("METAL3" "drawing") list(89.99:54.24 90.39:56.91))
dbCreateRect(cvid list("VIA12" "drawing") list(81.30:3.43 81.56:3.69))
dbCreateRect(cvid list("VIA12" "drawing") list(81.82:3.43 82.08:3.69))
dbCreateRect(cvid list("VIA12" "drawing") list(82.34:3.43 82.60:3.69))
dbCreateRect(cvid list("VIA12" "drawing") list(82.86:3.43 83.12:3.69))
dbCreateRect(cvid list("VIA12" "drawing") list(83.38:3.43 83.64:3.69))
dbCreateRect(cvid list("VIA12" "drawing") list(83.90:3.43 84.16:3.69))
dbCreateRect(cvid list("VIA12" "drawing") list(84.42:3.43 84.68:3.69))
dbCreateRect(cvid list("VIA12" "drawing") list(84.94:3.43 85.20:3.69))
dbCreateRect(cvid list("VIA12" "drawing") list(85.46:3.43 85.72:3.69))
dbCreateRect(cvid list("VIA12" "drawing") list(85.98:3.43 86.24:3.69))
dbCreateRect(cvid list("VIA12" "drawing") list(86.50:3.43 86.76:3.69))
dbCreateRect(cvid list("VIA12" "drawing") list(87.02:3.43 87.28:3.69))
dbCreateRect(cvid list("VIA12" "drawing") list(87.54:3.43 87.80:3.69))
dbCreateRect(cvid list("VIA12" "drawing") list(88.06:3.43 88.32:3.69))
dbCreateRect(cvid list("VIA12" "drawing") list(88.58:3.43 88.84:3.69))
dbCreateRect(cvid list("VIA12" "drawing") list(89.10:3.43 89.36:3.69))
dbCreateRect(cvid list("VIA12" "drawing") list(89.62:3.43 89.88:3.69))
dbCreateRect(cvid list("VIA12" "drawing") list(90.14:3.43 90.40:3.69))
dbCreateRect(cvid list("VIA12" "drawing") list(90.66:3.43 90.92:3.69))
dbCreateRect(cvid list("VIA12" "drawing") list(91.18:3.43 91.44:3.69))
dbCreateRect(cvid list("VIA12" "drawing") list(91.70:3.43 91.96:3.69))
dbCreateRect(cvid list("VIA12" "drawing") list(92.22:3.43 92.48:3.69))
dbCreateRect(cvid list("VIA12" "drawing") list(92.74:3.43 93.00:3.69))
dbCreateRect(cvid list("VIA12" "drawing") list(93.26:3.43 93.52:3.69))
dbCreateRect(cvid list("VIA12" "drawing") list(93.78:3.43 94.04:3.69))
dbCreateRect(cvid list("METAL1" "drawing") list(81.91:14.72 93.44:15.14))
dbCreateRect(cvid list("METAL2" "drawing") list(81.31:12.56 94.04:14.50))
dbCreateRect(cvid list("VIA12" "drawing") list(81.38:12.88 81.64:13.14))
dbCreateRect(cvid list("VIA12" "drawing") list(81.38:13.40 81.64:13.66))
dbCreateRect(cvid list("VIA12" "drawing") list(81.38:13.92 81.64:14.18))
dbCreateRect(cvid list("VIA12" "drawing") list(84.46:12.88 84.72:13.14))
dbCreateRect(cvid list("VIA12" "drawing") list(84.46:13.40 84.72:13.66))
dbCreateRect(cvid list("VIA12" "drawing") list(84.46:13.92 84.72:14.18))
dbCreateRect(cvid list("VIA12" "drawing") list(87.54:12.88 87.80:13.14))
dbCreateRect(cvid list("VIA12" "drawing") list(87.54:13.40 87.80:13.66))
dbCreateRect(cvid list("VIA12" "drawing") list(87.54:13.92 87.80:14.18))
dbCreateRect(cvid list("VIA12" "drawing") list(90.62:12.88 90.88:13.14))
dbCreateRect(cvid list("VIA12" "drawing") list(90.62:13.40 90.88:13.66))
dbCreateRect(cvid list("VIA12" "drawing") list(90.62:13.92 90.88:14.18))
dbCreateRect(cvid list("VIA12" "drawing") list(93.71:12.88 93.97:13.14))
dbCreateRect(cvid list("VIA12" "drawing") list(93.71:13.40 93.97:13.66))
dbCreateRect(cvid list("VIA12" "drawing") list(93.71:13.92 93.97:14.18))
dbCreateRect(cvid list("METAL2" "drawing") list(82.85:9.62 92.49:11.56))
dbCreateRect(cvid list("VIA12" "drawing") list(82.92:9.94 83.18:10.20))
dbCreateRect(cvid list("VIA12" "drawing") list(82.92:10.46 83.18:10.72))
dbCreateRect(cvid list("VIA12" "drawing") list(82.92:10.98 83.18:11.24))
dbCreateRect(cvid list("VIA12" "drawing") list(86.00:9.94 86.26:10.20))
dbCreateRect(cvid list("VIA12" "drawing") list(86.00:10.46 86.26:10.72))
dbCreateRect(cvid list("VIA12" "drawing") list(86.00:10.98 86.26:11.24))
dbCreateRect(cvid list("VIA12" "drawing") list(89.08:9.94 89.34:10.20))
dbCreateRect(cvid list("VIA12" "drawing") list(89.08:10.46 89.34:10.72))
dbCreateRect(cvid list("VIA12" "drawing") list(89.08:10.98 89.34:11.24))
dbCreateRect(cvid list("VIA12" "drawing") list(92.16:9.94 92.42:10.20))
dbCreateRect(cvid list("VIA12" "drawing") list(92.16:10.46 92.42:10.72))
dbCreateRect(cvid list("VIA12" "drawing") list(92.16:10.98 92.42:11.24))
dbCreateRect(cvid list("METAL3" "drawing") list(89.99:12.56 90.39:54.24))
dbCreateRect(cvid list("VIA23" "drawing") list(90.06:12.88 90.32:13.14))
dbCreateRect(cvid list("VIA23" "drawing") list(90.06:13.40 90.32:13.66))
dbCreateRect(cvid list("VIA23" "drawing") list(90.06:13.92 90.32:14.18))
dbCreateRect(cvid list("METAL3" "drawing") list(84.34:9.62 85.34:18.20))
dbCreateRect(cvid list("VIA23" "drawing") list(84.71:9.94 84.97:10.20))
dbCreateRect(cvid list("VIA23" "drawing") list(84.71:10.46 84.97:10.72))
dbCreateRect(cvid list("VIA23" "drawing") list(84.71:10.98 84.97:11.24))
dbCreateRect(cvid list("METAL2" "drawing") list(81.91:14.72 82.81:16.32))
dbCreateRect(cvid list("VIA12" "drawing") list(82.23:14.80 82.49:15.06))
dbCreateRect(cvid list("VIA12" "drawing") list(56.26:4.56 56.52:4.82))
dbCreateRect(cvid list("VIA12" "drawing") list(56.26:5.08 56.52:5.34))
dbCreateRect(cvid list("VIA12" "drawing") list(56.26:5.60 56.52:5.86))
dbCreateRect(cvid list("VIA12" "drawing") list(56.26:6.12 56.52:6.38))
dbCreateRect(cvid list("VIA12" "drawing") list(56.26:6.64 56.52:6.90))
dbCreateRect(cvid list("VIA12" "drawing") list(56.26:7.16 56.52:7.42))
dbCreateRect(cvid list("VIA12" "drawing") list(56.26:7.68 56.52:7.94))
dbCreateRect(cvid list("VIA12" "drawing") list(57.80:4.56 58.06:4.82))
dbCreateRect(cvid list("VIA12" "drawing") list(57.80:5.08 58.06:5.34))
dbCreateRect(cvid list("VIA12" "drawing") list(57.80:5.60 58.06:5.86))
dbCreateRect(cvid list("VIA12" "drawing") list(57.80:6.12 58.06:6.38))
dbCreateRect(cvid list("VIA12" "drawing") list(57.80:6.64 58.06:6.90))
dbCreateRect(cvid list("VIA12" "drawing") list(57.80:7.16 58.06:7.42))
dbCreateRect(cvid list("VIA12" "drawing") list(57.80:7.68 58.06:7.94))
dbCreateRect(cvid list("VIA12" "drawing") list(60.88:4.56 61.14:4.82))
dbCreateRect(cvid list("VIA12" "drawing") list(60.88:5.08 61.14:5.34))
dbCreateRect(cvid list("VIA12" "drawing") list(60.88:5.60 61.14:5.86))
dbCreateRect(cvid list("VIA12" "drawing") list(60.88:6.12 61.14:6.38))
dbCreateRect(cvid list("VIA12" "drawing") list(60.88:6.64 61.14:6.90))
dbCreateRect(cvid list("VIA12" "drawing") list(60.88:7.16 61.14:7.42))
dbCreateRect(cvid list("VIA12" "drawing") list(60.88:7.68 61.14:7.94))
dbCreateRect(cvid list("VIA12" "drawing") list(63.96:4.56 64.22:4.82))
dbCreateRect(cvid list("VIA12" "drawing") list(63.96:5.08 64.22:5.34))
dbCreateRect(cvid list("VIA12" "drawing") list(63.96:5.60 64.22:5.86))
dbCreateRect(cvid list("VIA12" "drawing") list(63.96:6.12 64.22:6.38))
dbCreateRect(cvid list("VIA12" "drawing") list(63.96:6.64 64.22:6.90))
dbCreateRect(cvid list("VIA12" "drawing") list(63.96:7.16 64.22:7.42))
dbCreateRect(cvid list("VIA12" "drawing") list(63.96:7.68 64.22:7.94))
dbCreateRect(cvid list("VIA12" "drawing") list(67.04:4.56 67.30:4.82))
dbCreateRect(cvid list("VIA12" "drawing") list(67.04:5.08 67.30:5.34))
dbCreateRect(cvid list("VIA12" "drawing") list(67.04:5.60 67.30:5.86))
dbCreateRect(cvid list("VIA12" "drawing") list(67.04:6.12 67.30:6.38))
dbCreateRect(cvid list("VIA12" "drawing") list(67.04:6.64 67.30:6.90))
dbCreateRect(cvid list("VIA12" "drawing") list(67.04:7.16 67.30:7.42))
dbCreateRect(cvid list("VIA12" "drawing") list(67.04:7.68 67.30:7.94))
dbCreateRect(cvid list("VIA12" "drawing") list(70.12:4.56 70.38:4.82))
dbCreateRect(cvid list("VIA12" "drawing") list(70.12:5.08 70.38:5.34))
dbCreateRect(cvid list("VIA12" "drawing") list(70.12:5.60 70.38:5.86))
dbCreateRect(cvid list("VIA12" "drawing") list(70.12:6.12 70.38:6.38))
dbCreateRect(cvid list("VIA12" "drawing") list(70.12:6.64 70.38:6.90))
dbCreateRect(cvid list("VIA12" "drawing") list(70.12:7.16 70.38:7.42))
dbCreateRect(cvid list("VIA12" "drawing") list(70.12:7.68 70.38:7.94))
dbCreateRect(cvid list("VIA12" "drawing") list(73.20:4.56 73.46:4.82))
dbCreateRect(cvid list("VIA12" "drawing") list(73.20:5.08 73.46:5.34))
dbCreateRect(cvid list("VIA12" "drawing") list(73.20:5.60 73.46:5.86))
dbCreateRect(cvid list("VIA12" "drawing") list(73.20:6.12 73.46:6.38))
dbCreateRect(cvid list("VIA12" "drawing") list(73.20:6.64 73.46:6.90))
dbCreateRect(cvid list("VIA12" "drawing") list(73.20:7.16 73.46:7.42))
dbCreateRect(cvid list("VIA12" "drawing") list(73.20:7.68 73.46:7.94))
dbCreateRect(cvid list("VIA12" "drawing") list(76.28:4.56 76.55:4.82))
dbCreateRect(cvid list("VIA12" "drawing") list(76.28:5.08 76.55:5.34))
dbCreateRect(cvid list("VIA12" "drawing") list(76.28:5.60 76.55:5.86))
dbCreateRect(cvid list("VIA12" "drawing") list(76.28:6.12 76.55:6.38))
dbCreateRect(cvid list("VIA12" "drawing") list(76.28:6.64 76.55:6.90))
dbCreateRect(cvid list("VIA12" "drawing") list(76.28:7.16 76.55:7.42))
dbCreateRect(cvid list("VIA12" "drawing") list(76.28:7.68 76.55:7.94))
dbCreateRect(cvid list("VIA12" "drawing") list(77.83:4.56 78.09:4.82))
dbCreateRect(cvid list("VIA12" "drawing") list(77.83:5.08 78.09:5.34))
dbCreateRect(cvid list("VIA12" "drawing") list(77.83:5.60 78.09:5.86))
dbCreateRect(cvid list("VIA12" "drawing") list(77.83:6.12 78.09:6.38))
dbCreateRect(cvid list("VIA12" "drawing") list(77.83:6.64 78.09:6.90))
dbCreateRect(cvid list("VIA12" "drawing") list(77.83:7.16 78.09:7.42))
dbCreateRect(cvid list("VIA12" "drawing") list(77.83:7.68 78.09:7.94))
dbCreateRect(cvid list("METAL1" "drawing") list(56.19:14.72 58.13:15.14))
dbCreateRect(cvid list("METAL1" "drawing") list(76.21:14.72 78.16:15.14))
dbCreateRect(cvid list("METAL1" "drawing") list(56.19:14.50 56.59:15.14))
dbCreateRect(cvid list("METAL1" "drawing") list(57.73:14.50 58.13:15.14))
dbCreateRect(cvid list("METAL1" "drawing") list(76.21:14.50 76.61:15.14))
dbCreateRect(cvid list("METAL1" "drawing") list(77.75:14.50 78.16:15.14))
dbCreateRect(cvid list("METAL1" "drawing") list(58.33:14.72 76.02:15.14))
dbCreateRect(cvid list("METAL2" "drawing") list(65.43:12.70 75.07:14.50))
dbCreateRect(cvid list("VIA12" "drawing") list(65.50:12.95 65.76:13.21))
dbCreateRect(cvid list("VIA12" "drawing") list(65.50:13.47 65.76:13.73))
dbCreateRect(cvid list("VIA12" "drawing") list(65.50:13.99 65.76:14.25))
dbCreateRect(cvid list("VIA12" "drawing") list(68.58:12.95 68.84:13.21))
dbCreateRect(cvid list("VIA12" "drawing") list(68.58:13.47 68.84:13.73))
dbCreateRect(cvid list("VIA12" "drawing") list(68.58:13.99 68.84:14.25))
dbCreateRect(cvid list("VIA12" "drawing") list(71.66:12.95 71.92:13.21))
dbCreateRect(cvid list("VIA12" "drawing") list(71.66:13.47 71.92:13.73))
dbCreateRect(cvid list("VIA12" "drawing") list(71.66:13.99 71.92:14.25))
dbCreateRect(cvid list("VIA12" "drawing") list(74.74:12.95 75.00:13.21))
dbCreateRect(cvid list("VIA12" "drawing") list(74.74:13.47 75.00:13.73))
dbCreateRect(cvid list("VIA12" "drawing") list(74.74:13.99 75.00:14.25))
dbCreateRect(cvid list("METAL2" "drawing") list(58.98:17.66 84.09:18.56))
dbCreateRect(cvid list("VIA12" "drawing") list(59.07:17.98 59.33:18.25))
dbCreateRect(cvid list("VIA12" "drawing") list(82.23:17.98 82.49:18.25))
dbCreateRect(cvid list("METAL2" "drawing") list(62.35:8.00 62.75:18.56))
dbCreateRect(cvid list("METAL3" "drawing") list(65.43:12.70 67.23:55.95))
dbCreateRect(cvid list("VIA23" "drawing") list(65.68:12.95 65.94:13.21))
dbCreateRect(cvid list("VIA23" "drawing") list(66.20:12.95 66.46:13.21))
dbCreateRect(cvid list("VIA23" "drawing") list(66.72:12.95 66.98:13.21))
dbCreateRect(cvid list("VIA23" "drawing") list(65.68:13.47 65.94:13.73))
dbCreateRect(cvid list("VIA23" "drawing") list(66.20:13.47 66.46:13.73))
dbCreateRect(cvid list("VIA23" "drawing") list(66.72:13.47 66.98:13.73))
dbCreateRect(cvid list("VIA23" "drawing") list(65.68:13.99 65.94:14.25))
dbCreateRect(cvid list("VIA23" "drawing") list(66.20:13.99 66.46:14.25))
dbCreateRect(cvid list("VIA23" "drawing") list(66.72:13.99 66.98:14.25))
dbCreateRect(cvid list("VIA23" "drawing") list(65.68:55.61 65.94:55.87))
dbCreateRect(cvid list("VIA23" "drawing") list(66.20:55.61 66.46:55.87))
dbCreateRect(cvid list("VIA23" "drawing") list(66.72:55.61 66.98:55.87))
dbCreateRect(cvid list("METAL2" "drawing") list(75.12:15.42 87.31:16.32))
dbCreateRect(cvid list("METAL2" "drawing") list(75.12:14.72 76.02:16.32))
dbCreateRect(cvid list("VIA12" "drawing") list(75.44:14.80 75.70:15.06))
dbCreateRect(cvid list("METAL3" "drawing") list(86.91:15.42 87.31:54.24))
dbCreateRect(cvid list("VIA12" "drawing") list(45.75:4.53 46.01:4.79))
dbCreateRect(cvid list("VIA12" "drawing") list(45.75:5.04 46.01:5.30))
dbCreateRect(cvid list("VIA12" "drawing") list(45.75:5.56 46.01:5.82))
dbCreateRect(cvid list("VIA12" "drawing") list(45.75:6.08 46.01:6.34))
dbCreateRect(cvid list("VIA12" "drawing") list(45.75:6.61 46.01:6.87))
dbCreateRect(cvid list("VIA12" "drawing") list(45.75:7.12 46.01:7.38))
dbCreateRect(cvid list("VIA12" "drawing") list(45.75:7.64 46.01:7.90))
dbCreateRect(cvid list("VIA12" "drawing") list(52.70:4.53 52.96:4.79))
dbCreateRect(cvid list("VIA12" "drawing") list(52.70:5.04 52.96:5.30))
dbCreateRect(cvid list("VIA12" "drawing") list(52.70:5.56 52.96:5.82))
dbCreateRect(cvid list("VIA12" "drawing") list(52.70:6.08 52.96:6.34))
dbCreateRect(cvid list("VIA12" "drawing") list(52.70:6.61 52.96:6.87))
dbCreateRect(cvid list("VIA12" "drawing") list(52.70:7.12 52.96:7.38))
dbCreateRect(cvid list("VIA12" "drawing") list(52.70:7.64 52.96:7.90))
dbCreateRect(cvid list("METAL1" "drawing") list(45.68:19.05 47.82:19.47))
dbCreateRect(cvid list("METAL1" "drawing") list(50.90:19.05 53.04:19.47))
dbCreateRect(cvid list("METAL1" "drawing") list(45.68:18.83 46.08:19.47))
dbCreateRect(cvid list("METAL1" "drawing") list(47.42:18.83 47.82:19.47))
dbCreateRect(cvid list("METAL1" "drawing") list(50.90:18.83 51.30:19.47))
dbCreateRect(cvid list("METAL1" "drawing") list(52.63:18.83 53.04:19.47))
dbCreateRect(cvid list("METAL1" "drawing") list(48.01:19.05 50.70:19.47))
dbCreateRect(cvid list("METAL2" "drawing") list(52.63:20.33 57.23:20.87))
dbCreateRect(cvid list("METAL2" "drawing") list(52.63:4.43 53.04:20.87))
dbCreateRect(cvid list("METAL2" "drawing") list(4.65:11.16 53.04:13.10))
dbCreateRect(cvid list("VIA12" "drawing") list(52.70:11.48 52.96:11.74))
dbCreateRect(cvid list("VIA12" "drawing") list(52.70:12.00 52.96:12.26))
dbCreateRect(cvid list("VIA12" "drawing") list(52.70:12.52 52.96:12.78))
dbCreateRect(cvid list("METAL2" "drawing") list(9.73:15.10 51.30:17.04))
dbCreateRect(cvid list("VIA12" "drawing") list(50.97:15.42 51.23:15.68))
dbCreateRect(cvid list("VIA12" "drawing") list(50.97:15.94 51.23:16.20))
dbCreateRect(cvid list("VIA12" "drawing") list(50.97:16.46 51.23:16.72))
dbCreateRect(cvid list("VIA12" "drawing") list(29.64:4.56 29.91:4.82))
dbCreateRect(cvid list("VIA12" "drawing") list(29.64:5.08 29.91:5.34))
dbCreateRect(cvid list("VIA12" "drawing") list(29.64:5.60 29.91:5.86))
dbCreateRect(cvid list("VIA12" "drawing") list(29.64:6.12 29.91:6.38))
dbCreateRect(cvid list("VIA12" "drawing") list(29.64:6.64 29.91:6.90))
dbCreateRect(cvid list("VIA12" "drawing") list(29.64:7.16 29.91:7.42))
dbCreateRect(cvid list("VIA12" "drawing") list(29.64:7.68 29.91:7.94))
dbCreateRect(cvid list("VIA12" "drawing") list(31.39:4.56 31.65:4.82))
dbCreateRect(cvid list("VIA12" "drawing") list(31.39:5.08 31.65:5.34))
dbCreateRect(cvid list("VIA12" "drawing") list(31.39:5.60 31.65:5.86))
dbCreateRect(cvid list("VIA12" "drawing") list(31.39:6.12 31.65:6.38))
dbCreateRect(cvid list("VIA12" "drawing") list(31.39:6.64 31.65:6.90))
dbCreateRect(cvid list("VIA12" "drawing") list(31.39:7.16 31.65:7.42))
dbCreateRect(cvid list("VIA12" "drawing") list(31.39:7.68 31.65:7.94))
dbCreateRect(cvid list("VIA12" "drawing") list(34.87:4.56 35.12:4.82))
dbCreateRect(cvid list("VIA12" "drawing") list(34.87:5.08 35.12:5.34))
dbCreateRect(cvid list("VIA12" "drawing") list(34.87:5.60 35.12:5.86))
dbCreateRect(cvid list("VIA12" "drawing") list(34.87:6.12 35.12:6.38))
dbCreateRect(cvid list("VIA12" "drawing") list(34.87:6.64 35.12:6.90))
dbCreateRect(cvid list("VIA12" "drawing") list(34.87:7.16 35.12:7.42))
dbCreateRect(cvid list("VIA12" "drawing") list(34.87:7.68 35.12:7.94))
dbCreateRect(cvid list("VIA12" "drawing") list(38.34:4.56 38.60:4.82))
dbCreateRect(cvid list("VIA12" "drawing") list(38.34:5.08 38.60:5.34))
dbCreateRect(cvid list("VIA12" "drawing") list(38.34:5.60 38.60:5.86))
dbCreateRect(cvid list("VIA12" "drawing") list(38.34:6.12 38.60:6.38))
dbCreateRect(cvid list("VIA12" "drawing") list(38.34:6.64 38.60:6.90))
dbCreateRect(cvid list("VIA12" "drawing") list(38.34:7.16 38.60:7.42))
dbCreateRect(cvid list("VIA12" "drawing") list(38.34:7.68 38.60:7.94))
dbCreateRect(cvid list("VIA12" "drawing") list(40.08:4.56 40.34:4.82))
dbCreateRect(cvid list("VIA12" "drawing") list(40.08:5.08 40.34:5.34))
dbCreateRect(cvid list("VIA12" "drawing") list(40.08:5.60 40.34:5.86))
dbCreateRect(cvid list("VIA12" "drawing") list(40.08:6.12 40.34:6.38))
dbCreateRect(cvid list("VIA12" "drawing") list(40.08:6.64 40.34:6.90))
dbCreateRect(cvid list("VIA12" "drawing") list(40.08:7.16 40.34:7.42))
dbCreateRect(cvid list("VIA12" "drawing") list(40.08:7.68 40.34:7.94))
dbCreateRect(cvid list("METAL1" "drawing") list(29.57:19.72 31.71:20.14))
dbCreateRect(cvid list("METAL1" "drawing") list(38.27:19.72 40.41:20.14))
dbCreateRect(cvid list("METAL1" "drawing") list(29.57:19.50 29.97:20.14))
dbCreateRect(cvid list("METAL1" "drawing") list(31.32:19.50 31.71:20.14))
dbCreateRect(cvid list("METAL1" "drawing") list(38.27:19.50 38.68:20.14))
dbCreateRect(cvid list("METAL1" "drawing") list(40.01:19.50 40.41:20.14))
dbCreateRect(cvid list("METAL1" "drawing") list(31.91:19.72 38.08:20.14))
dbCreateRect(cvid list("METAL2" "drawing") list(33.05:17.56 36.94:19.50))
dbCreateRect(cvid list("VIA12" "drawing") list(33.12:17.88 33.38:18.14))
dbCreateRect(cvid list("VIA12" "drawing") list(33.12:18.40 33.38:18.66))
dbCreateRect(cvid list("VIA12" "drawing") list(33.12:18.92 33.38:19.18))
dbCreateRect(cvid list("VIA12" "drawing") list(36.60:17.88 36.86:18.14))
dbCreateRect(cvid list("VIA12" "drawing") list(36.60:18.40 36.86:18.66))
dbCreateRect(cvid list("VIA12" "drawing") list(36.60:18.92 36.86:19.18))
dbCreateRect(cvid list("METAL3" "drawing") list(31.91:11.16 32.81:20.14))
dbCreateRect(cvid list("VIA12" "drawing") list(32.23:11.48 32.49:11.74))
dbCreateRect(cvid list("VIA12" "drawing") list(32.23:12.00 32.49:12.26))
dbCreateRect(cvid list("VIA12" "drawing") list(32.23:12.52 32.49:12.78))
dbCreateRect(cvid list("VIA12" "drawing") list(32.23:19.80 32.49:20.06))
dbCreateRect(cvid list("VIA23" "drawing") list(32.23:11.48 32.49:11.74))
dbCreateRect(cvid list("VIA23" "drawing") list(32.23:12.00 32.49:12.26))
dbCreateRect(cvid list("VIA23" "drawing") list(32.23:12.52 32.49:12.78))
dbCreateRect(cvid list("VIA23" "drawing") list(32.23:19.80 32.49:20.06))
dbCreateRect(cvid list("METAL5" "drawing") list(35.00:17.56 36.94:37.46))
dbCreateRect(cvid list("METAL4" "drawing") list(35.00:17.56 36.94:19.50))
dbCreateRect(cvid list("METAL3" "drawing") list(35.00:17.56 36.94:19.50))
dbCreateRect(cvid list("VIA23" "drawing") list(35.31:17.88 35.57:18.14))
dbCreateRect(cvid list("VIA23" "drawing") list(35.84:17.88 36.09:18.14))
dbCreateRect(cvid list("VIA23" "drawing") list(36.36:17.88 36.62:18.14))
dbCreateRect(cvid list("VIA23" "drawing") list(35.31:18.40 35.57:18.66))
dbCreateRect(cvid list("VIA23" "drawing") list(35.84:18.40 36.09:18.66))
dbCreateRect(cvid list("VIA23" "drawing") list(36.36:18.40 36.62:18.66))
dbCreateRect(cvid list("VIA23" "drawing") list(35.31:18.92 35.57:19.18))
dbCreateRect(cvid list("VIA23" "drawing") list(35.84:18.92 36.09:19.18))
dbCreateRect(cvid list("VIA23" "drawing") list(36.36:18.92 36.62:19.18))
dbCreateRect(cvid list("VIA34" "drawing") list(35.31:17.88 35.57:18.14))
dbCreateRect(cvid list("VIA34" "drawing") list(35.84:17.88 36.09:18.14))
dbCreateRect(cvid list("VIA34" "drawing") list(36.36:17.88 36.62:18.14))
dbCreateRect(cvid list("VIA34" "drawing") list(35.31:18.40 35.57:18.66))
dbCreateRect(cvid list("VIA34" "drawing") list(35.84:18.40 36.09:18.66))
dbCreateRect(cvid list("VIA34" "drawing") list(36.36:18.40 36.62:18.66))
dbCreateRect(cvid list("VIA34" "drawing") list(35.31:18.92 35.57:19.18))
dbCreateRect(cvid list("VIA34" "drawing") list(35.84:18.92 36.09:19.18))
dbCreateRect(cvid list("VIA34" "drawing") list(36.36:18.92 36.62:19.18))
dbCreateRect(cvid list("VIA45" "drawing") list(35.31:17.88 35.57:18.14))
dbCreateRect(cvid list("VIA45" "drawing") list(35.84:17.88 36.09:18.14))
dbCreateRect(cvid list("VIA45" "drawing") list(36.36:17.88 36.62:18.14))
dbCreateRect(cvid list("VIA45" "drawing") list(35.31:18.40 35.57:18.66))
dbCreateRect(cvid list("VIA45" "drawing") list(35.84:18.40 36.09:18.66))
dbCreateRect(cvid list("VIA45" "drawing") list(36.36:18.40 36.62:18.66))
dbCreateRect(cvid list("VIA45" "drawing") list(35.31:18.92 35.57:19.18))
dbCreateRect(cvid list("VIA45" "drawing") list(35.84:18.92 36.09:19.18))
dbCreateRect(cvid list("VIA45" "drawing") list(36.36:18.92 36.62:19.18))
dbCreateRect(cvid list("METAL3" "drawing") list(20.89:47.42 22.83:60.11))
dbCreateRect(cvid list("METAL2" "drawing") list(2.11:47.42 22.83:49.36))
dbCreateRect(cvid list("VIA23" "drawing") list(21.21:58.49 21.47:58.75))
dbCreateRect(cvid list("VIA23" "drawing") list(21.73:58.49 21.99:58.75))
dbCreateRect(cvid list("VIA23" "drawing") list(22.25:58.49 22.51:58.75))
dbCreateRect(cvid list("VIA23" "drawing") list(21.21:59.01 21.47:59.27))
dbCreateRect(cvid list("VIA23" "drawing") list(21.73:59.01 21.99:59.27))
dbCreateRect(cvid list("VIA23" "drawing") list(22.25:59.01 22.51:59.27))
dbCreateRect(cvid list("VIA23" "drawing") list(21.21:59.53 21.47:59.79))
dbCreateRect(cvid list("VIA23" "drawing") list(21.73:59.53 21.99:59.79))
dbCreateRect(cvid list("VIA23" "drawing") list(22.25:59.53 22.51:59.79))
dbCreateRect(cvid list("VIA23" "drawing") list(21.21:47.74 21.47:48.00))
dbCreateRect(cvid list("VIA23" "drawing") list(21.73:47.74 21.99:48.00))
dbCreateRect(cvid list("VIA23" "drawing") list(22.25:47.74 22.51:48.00))
dbCreateRect(cvid list("VIA23" "drawing") list(21.21:48.26 21.47:48.52))
dbCreateRect(cvid list("VIA23" "drawing") list(21.73:48.26 21.99:48.52))
dbCreateRect(cvid list("VIA23" "drawing") list(22.25:48.26 22.51:48.52))
dbCreateRect(cvid list("VIA23" "drawing") list(21.21:48.78 21.47:49.04))
dbCreateRect(cvid list("VIA23" "drawing") list(21.73:48.78 21.99:49.04))
dbCreateRect(cvid list("VIA23" "drawing") list(22.25:48.78 22.51:49.04))
dbCreateRect(cvid list("METAL3" "drawing") list(20.89:15.10 22.83:45.42))
dbCreateRect(cvid list("METAL2" "drawing") list(9.73:15.10 22.83:17.04))
dbCreateRect(cvid list("METAL2" "drawing") list(4.65:43.48 22.83:45.42))
dbCreateRect(cvid list("VIA23" "drawing") list(21.21:15.42 21.47:15.68))
dbCreateRect(cvid list("VIA23" "drawing") list(21.73:15.42 21.99:15.68))
dbCreateRect(cvid list("VIA23" "drawing") list(22.25:15.42 22.51:15.68))
dbCreateRect(cvid list("VIA23" "drawing") list(21.21:15.94 21.47:16.20))
dbCreateRect(cvid list("VIA23" "drawing") list(21.73:15.94 21.99:16.20))
dbCreateRect(cvid list("VIA23" "drawing") list(22.25:15.94 22.51:16.20))
dbCreateRect(cvid list("VIA23" "drawing") list(21.21:16.46 21.47:16.72))
dbCreateRect(cvid list("VIA23" "drawing") list(21.73:16.46 21.99:16.72))
dbCreateRect(cvid list("VIA23" "drawing") list(22.25:16.46 22.51:16.72))
dbCreateRect(cvid list("VIA23" "drawing") list(21.21:43.80 21.47:44.06))
dbCreateRect(cvid list("VIA23" "drawing") list(21.73:43.80 21.99:44.06))
dbCreateRect(cvid list("VIA23" "drawing") list(22.25:43.80 22.51:44.06))
dbCreateRect(cvid list("VIA23" "drawing") list(21.21:44.32 21.47:44.58))
dbCreateRect(cvid list("VIA23" "drawing") list(21.73:44.32 21.99:44.58))
dbCreateRect(cvid list("VIA23" "drawing") list(22.25:44.32 22.51:44.58))
dbCreateRect(cvid list("VIA23" "drawing") list(21.21:44.84 21.47:45.10))
dbCreateRect(cvid list("VIA23" "drawing") list(21.73:44.84 21.99:45.10))
dbCreateRect(cvid list("VIA23" "drawing") list(22.25:44.84 22.51:45.10))
dbCreateRect(cvid list("METAL3" "drawing") list(23.11:11.16 25.05:41.48))
dbCreateRect(cvid list("METAL2" "drawing") list(9.73:39.54 25.05:41.48))
dbCreateRect(cvid list("VIA23" "drawing") list(23.43:39.86 23.69:40.12))
dbCreateRect(cvid list("VIA23" "drawing") list(23.95:39.86 24.21:40.12))
dbCreateRect(cvid list("VIA23" "drawing") list(24.47:39.86 24.73:40.12))
dbCreateRect(cvid list("VIA23" "drawing") list(23.43:40.38 23.69:40.64))
dbCreateRect(cvid list("VIA23" "drawing") list(23.95:40.38 24.21:40.64))
dbCreateRect(cvid list("VIA23" "drawing") list(24.47:40.38 24.73:40.64))
dbCreateRect(cvid list("VIA23" "drawing") list(23.43:40.90 23.69:41.16))
dbCreateRect(cvid list("VIA23" "drawing") list(23.95:40.90 24.21:41.16))
dbCreateRect(cvid list("VIA23" "drawing") list(24.47:40.90 24.73:41.16))
dbCreateRect(cvid list("VIA23" "drawing") list(23.43:11.48 23.69:11.74))
dbCreateRect(cvid list("VIA23" "drawing") list(23.95:11.48 24.21:11.74))
dbCreateRect(cvid list("VIA23" "drawing") list(24.47:11.48 24.73:11.74))
dbCreateRect(cvid list("VIA23" "drawing") list(23.43:12.00 23.69:12.26))
dbCreateRect(cvid list("VIA23" "drawing") list(23.95:12.00 24.21:12.26))
dbCreateRect(cvid list("VIA23" "drawing") list(24.47:12.00 24.73:12.26))
dbCreateRect(cvid list("VIA23" "drawing") list(23.43:12.52 23.69:12.78))
dbCreateRect(cvid list("VIA23" "drawing") list(23.95:12.52 24.21:12.78))
dbCreateRect(cvid list("VIA23" "drawing") list(24.47:12.52 24.73:12.78))
dbCreateRect(cvid list("METAL3" "drawing") list(25.33:7.22 27.27:49.36))
dbCreateRect(cvid list("METAL2" "drawing") list(2.11:47.42 27.27:49.36))
dbCreateRect(cvid list("METAL2" "drawing") list(2.11:7.22 27.27:9.16))
dbCreateRect(cvid list("VIA23" "drawing") list(25.65:47.74 25.91:48.00))
dbCreateRect(cvid list("VIA23" "drawing") list(26.17:47.74 26.43:48.00))
dbCreateRect(cvid list("VIA23" "drawing") list(26.69:47.74 26.95:48.00))
dbCreateRect(cvid list("VIA23" "drawing") list(25.65:48.26 25.91:48.52))
dbCreateRect(cvid list("VIA23" "drawing") list(26.17:48.26 26.43:48.52))
dbCreateRect(cvid list("VIA23" "drawing") list(26.69:48.26 26.95:48.52))
dbCreateRect(cvid list("VIA23" "drawing") list(25.65:48.78 25.91:49.04))
dbCreateRect(cvid list("VIA23" "drawing") list(26.17:48.78 26.43:49.04))
dbCreateRect(cvid list("VIA23" "drawing") list(26.69:48.78 26.95:49.04))
dbCreateRect(cvid list("VIA23" "drawing") list(25.65:7.54 25.91:7.80))
dbCreateRect(cvid list("VIA23" "drawing") list(26.17:7.54 26.43:7.80))
dbCreateRect(cvid list("VIA23" "drawing") list(26.69:7.54 26.95:7.80))
dbCreateRect(cvid list("VIA23" "drawing") list(25.65:8.06 25.91:8.32))
dbCreateRect(cvid list("VIA23" "drawing") list(26.17:8.06 26.43:8.32))
dbCreateRect(cvid list("VIA23" "drawing") list(26.69:8.06 26.95:8.32))
dbCreateRect(cvid list("VIA23" "drawing") list(25.65:8.58 25.91:8.84))
dbCreateRect(cvid list("VIA23" "drawing") list(26.17:8.58 26.43:8.84))
dbCreateRect(cvid list("VIA23" "drawing") list(26.69:8.58 26.95:8.84))
dbCreateRect(cvid list("METAL6" "drawing") list(44.61:35.46 77.41:39.46))
dbCreateRect(cvid list("METAL6" "drawing") list(57.48:20.33 58.48:37.46))
dbCreateRect(cvid list("METAL5" "drawing") list(57.48:20.33 58.48:21.33))
dbCreateRect(cvid list("METAL4" "drawing") list(57.48:20.33 58.48:21.33))
dbCreateRect(cvid list("METAL3" "drawing") list(57.48:20.33 58.48:21.33))
dbCreateRect(cvid list("METAL2" "drawing") list(57.48:20.33 58.48:21.33))
dbCreateRect(cvid list("VIA56" "drawing") list(57.84:20.70 58.10:20.96))
dbCreateRect(cvid list("VIA45" "drawing") list(57.84:20.70 58.10:20.96))
dbCreateRect(cvid list("VIA34" "drawing") list(57.84:20.70 58.10:20.96))
dbCreateRect(cvid list("VIA23" "drawing") list(57.84:20.70 58.10:20.96))
dbCreateRect(cvid list("METAL6" "drawing") list(37.67:37.46 39.67:60.11))
dbCreateRect(cvid list("METAL5" "drawing") list(37.67:58.17 39.67:60.11))
dbCreateRect(cvid list("METAL4" "drawing") list(37.67:58.17 39.67:60.11))
dbCreateRect(cvid list("METAL3" "drawing") list(37.67:58.17 39.67:60.11))
dbCreateRect(cvid list("VIA56" "drawing") list(38.02:58.49 38.28:58.75))
dbCreateRect(cvid list("VIA56" "drawing") list(38.54:58.49 38.80:58.75))
dbCreateRect(cvid list("VIA56" "drawing") list(39.06:58.49 39.32:58.75))
dbCreateRect(cvid list("VIA56" "drawing") list(38.02:59.01 38.28:59.27))
dbCreateRect(cvid list("VIA56" "drawing") list(38.54:59.01 38.80:59.27))
dbCreateRect(cvid list("VIA56" "drawing") list(39.06:59.01 39.32:59.27))
dbCreateRect(cvid list("VIA56" "drawing") list(38.02:59.53 38.28:59.79))
dbCreateRect(cvid list("VIA56" "drawing") list(38.54:59.53 38.80:59.79))
dbCreateRect(cvid list("VIA56" "drawing") list(39.06:59.53 39.32:59.79))
dbCreateRect(cvid list("VIA45" "drawing") list(38.02:58.49 38.28:58.75))
dbCreateRect(cvid list("VIA45" "drawing") list(38.54:58.49 38.80:58.75))
dbCreateRect(cvid list("VIA45" "drawing") list(39.06:58.49 39.32:58.75))
dbCreateRect(cvid list("VIA45" "drawing") list(38.02:59.01 38.28:59.27))
dbCreateRect(cvid list("VIA45" "drawing") list(38.54:59.01 38.80:59.27))
dbCreateRect(cvid list("VIA45" "drawing") list(39.06:59.01 39.32:59.27))
dbCreateRect(cvid list("VIA45" "drawing") list(38.02:59.53 38.28:59.79))
dbCreateRect(cvid list("VIA45" "drawing") list(38.54:59.53 38.80:59.79))
dbCreateRect(cvid list("VIA45" "drawing") list(39.06:59.53 39.32:59.79))
dbCreateRect(cvid list("VIA34" "drawing") list(38.02:58.49 38.28:58.75))
dbCreateRect(cvid list("VIA34" "drawing") list(38.54:58.49 38.80:58.75))
dbCreateRect(cvid list("VIA34" "drawing") list(39.06:58.49 39.32:58.75))
dbCreateRect(cvid list("VIA34" "drawing") list(38.02:59.01 38.28:59.27))
dbCreateRect(cvid list("VIA34" "drawing") list(38.54:59.01 38.80:59.27))
dbCreateRect(cvid list("VIA34" "drawing") list(39.06:59.01 39.32:59.27))
dbCreateRect(cvid list("VIA34" "drawing") list(38.02:59.53 38.28:59.79))
dbCreateRect(cvid list("VIA34" "drawing") list(38.54:59.53 38.80:59.79))
dbCreateRect(cvid list("VIA34" "drawing") list(39.06:59.53 39.32:59.79))
dbCreateRect(cvid list("VIA23" "drawing") list(38.02:58.49 38.28:58.75))
dbCreateRect(cvid list("VIA23" "drawing") list(38.54:58.49 38.80:58.75))
dbCreateRect(cvid list("VIA23" "drawing") list(39.06:58.49 39.32:58.75))
dbCreateRect(cvid list("VIA23" "drawing") list(38.02:59.01 38.28:59.27))
dbCreateRect(cvid list("VIA23" "drawing") list(38.54:59.01 38.80:59.27))
dbCreateRect(cvid list("VIA23" "drawing") list(39.06:59.01 39.32:59.27))
dbCreateRect(cvid list("VIA23" "drawing") list(38.02:59.53 38.28:59.79))
dbCreateRect(cvid list("VIA23" "drawing") list(38.54:59.53 38.80:59.79))
dbCreateRect(cvid list("VIA23" "drawing") list(39.06:59.53 39.32:59.79))
