insts=cv->instances
inst=car(setof(a insts a->name=="M14"))
instCdf=cdfGetInstCDF(inst)
cdfFindParamByName(instCdf "l")~>value="1u"
inst=car(setof(a insts a->name=="M14"))
instCdf=cdfGetInstCDF(inst)
cdfFindParamByName(instCdf "w")~>value="10u"
inst=car(setof(a insts a->name=="M14"))
instCdf=cdfGetInstCDF(inst)
cdfFindParamByName(instCdf "m")~>value="4"
inst=car(setof(a insts a->name=="M13"))
instCdf=cdfGetInstCDF(inst)
cdfFindParamByName(instCdf "l")~>value="1u"
inst=car(setof(a insts a->name=="M13"))
instCdf=cdfGetInstCDF(inst)
cdfFindParamByName(instCdf "w")~>value="10u"
inst=car(setof(a insts a->name=="M13"))
instCdf=cdfGetInstCDF(inst)
cdfFindParamByName(instCdf "m")~>value="4"
inst=car(setof(a insts a->name=="M26"))
instCdf=cdfGetInstCDF(inst)
cdfFindParamByName(instCdf "l")~>value="1u"
inst=car(setof(a insts a->name=="M26"))
instCdf=cdfGetInstCDF(inst)
cdfFindParamByName(instCdf "w")~>value="10u"
inst=car(setof(a insts a->name=="M26"))
instCdf=cdfGetInstCDF(inst)
cdfFindParamByName(instCdf "m")~>value="4"
inst=car(setof(a insts a->name=="M30"))
instCdf=cdfGetInstCDF(inst)
cdfFindParamByName(instCdf "l")~>value="2u"
inst=car(setof(a insts a->name=="M30"))
instCdf=cdfGetInstCDF(inst)
cdfFindParamByName(instCdf "w")~>value="21.0u"
inst=car(setof(a insts a->name=="M30"))
instCdf=cdfGetInstCDF(inst)
cdfFindParamByName(instCdf "m")~>value="2"
inst=car(setof(a insts a->name=="M29"))
instCdf=cdfGetInstCDF(inst)
cdfFindParamByName(instCdf "l")~>value="2u"
inst=car(setof(a insts a->name=="M29"))
instCdf=cdfGetInstCDF(inst)
cdfFindParamByName(instCdf "w")~>value="21.0u"
inst=car(setof(a insts a->name=="M29"))
instCdf=cdfGetInstCDF(inst)
cdfFindParamByName(instCdf "m")~>value="2"
inst=car(setof(a insts a->name=="M25"))
instCdf=cdfGetInstCDF(inst)
cdfFindParamByName(instCdf "l")~>value="2u"
inst=car(setof(a insts a->name=="M25"))
instCdf=cdfGetInstCDF(inst)
cdfFindParamByName(instCdf "w")~>value="21.0u"
inst=car(setof(a insts a->name=="M25"))
instCdf=cdfGetInstCDF(inst)
cdfFindParamByName(instCdf "m")~>value="2"
inst=car(setof(a insts a->name=="M4"))
instCdf=cdfGetInstCDF(inst)
cdfFindParamByName(instCdf "l")~>value="2u"
inst=car(setof(a insts a->name=="M4"))
instCdf=cdfGetInstCDF(inst)
cdfFindParamByName(instCdf "w")~>value="21.0u"
inst=car(setof(a insts a->name=="M4"))
instCdf=cdfGetInstCDF(inst)
cdfFindParamByName(instCdf "m")~>value="4"
inst=car(setof(a insts a->name=="M18"))
instCdf=cdfGetInstCDF(inst)
cdfFindParamByName(instCdf "l")~>value="2u"
inst=car(setof(a insts a->name=="M18"))
instCdf=cdfGetInstCDF(inst)
cdfFindParamByName(instCdf "w")~>value="21.0u"
inst=car(setof(a insts a->name=="M18"))
instCdf=cdfGetInstCDF(inst)
cdfFindParamByName(instCdf "m")~>value="4"
inst=car(setof(a insts a->name=="M19"))
instCdf=cdfGetInstCDF(inst)
cdfFindParamByName(instCdf "l")~>value="2u"
inst=car(setof(a insts a->name=="M19"))
instCdf=cdfGetInstCDF(inst)
cdfFindParamByName(instCdf "w")~>value="21.0u"
inst=car(setof(a insts a->name=="M19"))
instCdf=cdfGetInstCDF(inst)
cdfFindParamByName(instCdf "m")~>value="4"
inst=car(setof(a insts a->name=="M20"))
instCdf=cdfGetInstCDF(inst)
cdfFindParamByName(instCdf "l")~>value="2u"
inst=car(setof(a insts a->name=="M20"))
instCdf=cdfGetInstCDF(inst)
cdfFindParamByName(instCdf "w")~>value="21.0u"
inst=car(setof(a insts a->name=="M20"))
instCdf=cdfGetInstCDF(inst)
cdfFindParamByName(instCdf "m")~>value="8"
inst=car(setof(a insts a->name=="M21"))
instCdf=cdfGetInstCDF(inst)
cdfFindParamByName(instCdf "l")~>value="2u"
inst=car(setof(a insts a->name=="M21"))
instCdf=cdfGetInstCDF(inst)
cdfFindParamByName(instCdf "w")~>value="21.0u"
inst=car(setof(a insts a->name=="M21"))
instCdf=cdfGetInstCDF(inst)
cdfFindParamByName(instCdf "m")~>value="16"
inst=car(setof(a insts a->name=="M16"))
instCdf=cdfGetInstCDF(inst)
cdfFindParamByName(instCdf "l")~>value="1u"
inst=car(setof(a insts a->name=="M16"))
instCdf=cdfGetInstCDF(inst)
cdfFindParamByName(instCdf "w")~>value="10u"
inst=car(setof(a insts a->name=="M16"))
instCdf=cdfGetInstCDF(inst)
cdfFindParamByName(instCdf "m")~>value="4"
inst=car(setof(a insts a->name=="M15"))
instCdf=cdfGetInstCDF(inst)
cdfFindParamByName(instCdf "l")~>value="1u"
inst=car(setof(a insts a->name=="M15"))
instCdf=cdfGetInstCDF(inst)
cdfFindParamByName(instCdf "w")~>value="10u"
inst=car(setof(a insts a->name=="M15"))
instCdf=cdfGetInstCDF(inst)
cdfFindParamByName(instCdf "m")~>value="8"
inst=car(setof(a insts a->name=="M24"))
instCdf=cdfGetInstCDF(inst)
cdfFindParamByName(instCdf "l")~>value="1.2u"
inst=car(setof(a insts a->name=="M24"))
instCdf=cdfGetInstCDF(inst)
cdfFindParamByName(instCdf "w")~>value="15.0u"
inst=car(setof(a insts a->name=="M24"))
instCdf=cdfGetInstCDF(inst)
cdfFindParamByName(instCdf "m")~>value="2"
inst=car(setof(a insts a->name=="M23"))
instCdf=cdfGetInstCDF(inst)
cdfFindParamByName(instCdf "l")~>value="1.2u"
inst=car(setof(a insts a->name=="M23"))
instCdf=cdfGetInstCDF(inst)
cdfFindParamByName(instCdf "w")~>value="14.4u"
inst=car(setof(a insts a->name=="M23"))
instCdf=cdfGetInstCDF(inst)
cdfFindParamByName(instCdf "m")~>value="2"
inst=car(setof(a insts a->name=="M17"))
instCdf=cdfGetInstCDF(inst)
cdfFindParamByName(instCdf "l")~>value="1u"
inst=car(setof(a insts a->name=="M17"))
instCdf=cdfGetInstCDF(inst)
cdfFindParamByName(instCdf "w")~>value="10u"
inst=car(setof(a insts a->name=="M17"))
instCdf=cdfGetInstCDF(inst)
cdfFindParamByName(instCdf "m")~>value="8"
inst=car(setof(a insts a->name=="M22"))
instCdf=cdfGetInstCDF(inst)
cdfFindParamByName(instCdf "l")~>value="1u"
inst=car(setof(a insts a->name=="M22"))
instCdf=cdfGetInstCDF(inst)
cdfFindParamByName(instCdf "w")~>value="10u"
inst=car(setof(a insts a->name=="M22"))
instCdf=cdfGetInstCDF(inst)
cdfFindParamByName(instCdf "m")~>value="2"
inst=car(setof(a insts a->name=="M7"))
instCdf=cdfGetInstCDF(inst)
cdfFindParamByName(instCdf "l")~>value="1.2u"
inst=car(setof(a insts a->name=="M7"))
instCdf=cdfGetInstCDF(inst)
cdfFindParamByName(instCdf "w")~>value="15.0u"
inst=car(setof(a insts a->name=="M7"))
instCdf=cdfGetInstCDF(inst)
cdfFindParamByName(instCdf "m")~>value="4"
inst=car(setof(a insts a->name=="M6"))
instCdf=cdfGetInstCDF(inst)
cdfFindParamByName(instCdf "l")~>value="1.2u"
inst=car(setof(a insts a->name=="M6"))
instCdf=cdfGetInstCDF(inst)
cdfFindParamByName(instCdf "w")~>value="14.4u"
inst=car(setof(a insts a->name=="M6"))
instCdf=cdfGetInstCDF(inst)
cdfFindParamByName(instCdf "m")~>value="1"
inst=car(setof(a insts a->name=="M5"))
instCdf=cdfGetInstCDF(inst)
cdfFindParamByName(instCdf "l")~>value="1.2u"
inst=car(setof(a insts a->name=="M5"))
instCdf=cdfGetInstCDF(inst)
cdfFindParamByName(instCdf "w")~>value="14.4u"
inst=car(setof(a insts a->name=="M5"))
instCdf=cdfGetInstCDF(inst)
cdfFindParamByName(instCdf "m")~>value="1"
inst=car(setof(a insts a->name=="C1"))
instCdf=cdfGetInstCDF(inst)
cdfFindParamByName(instCdf "l")~>value="28.0u"
inst=car(setof(a insts a->name=="C1"))
instCdf=cdfGetInstCDF(inst)
cdfFindParamByName(instCdf "w")~>value="28.0u"
inst=car(setof(a insts a->name=="C1"))
instCdf=cdfGetInstCDF(inst)
cdfFindParamByName(instCdf "m")~>value="2"
inst=car(setof(a insts a->name=="R3"))
instCdf=cdfGetInstCDF(inst)
cdfFindParamByName(instCdf "l")~>value="2.38u"
inst=car(setof(a insts a->name=="R3"))
instCdf=cdfGetInstCDF(inst)
cdfFindParamByName(instCdf "w")~>value="1u"
inst=car(setof(a insts a->name=="R3"))
instCdf=cdfGetInstCDF(inst)
cdfFindParamByName(instCdf "segments")~>value="2"
inst=car(setof(a insts a->name=="R2"))
instCdf=cdfGetInstCDF(inst)
cdfFindParamByName(instCdf "l")~>value="2.1u"
inst=car(setof(a insts a->name=="R2"))
instCdf=cdfGetInstCDF(inst)
cdfFindParamByName(instCdf "w")~>value="1u"
inst=car(setof(a insts a->name=="R2"))
instCdf=cdfGetInstCDF(inst)
cdfFindParamByName(instCdf "segments")~>value="2"
