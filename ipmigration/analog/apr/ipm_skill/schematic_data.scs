// Design: demo_ipm_tsmc018/test1
simulator lang=spectre
global 0
include "/home/meow/projects/ip_migration/pdks/smic18mmrf/smic18mmrf/../models/spectre/ms018_v1p7_spe.lib" section=tt
include "/home/meow/projects/ip_migration/pdks/smic18mmrf/smic18mmrf/../models/spectre/ms018_v1p7_spe.lib" section=bjt_tt
include "/home/meow/projects/ip_migration/pdks/smic18mmrf/smic18mmrf/../models/spectre/ms018_v1p7_spe.lib" section=res_tt
include "/home/meow/projects/ip_migration/pdks/smic18mmrf/smic18mmrf/../models/spectre/ms018_v1p7_spe.lib" section=mim_tt
include "/home/meow/projects/ip_migration/pdks/smic18mmrf/smic18mmrf/../models/spectre/ms018_v1p7_res_spe.ckt"
include "/home/meow/projects/ip_migration/pdks/smic18mmrf/smic18mmrf/../models/spectre/ms018_rf_v1p5_spe.lib" section=tt
include "/home/meow/projects/ip_migration/pdks/smic18mmrf/smic18mmrf/../models/spectre/ms018_rf_v1p5_spe.lib" section=res_tt
include "/home/meow/projects/ip_migration/pdks/smic18mmrf/smic18mmrf/../models/spectre/ms018_rf_v1p5_spe.lib" section=mim_tt
include "/home/meow/projects/ip_migration/pdks/smic18mmrf/smic18mmrf/../models/spectre/rf018_m6_res_spe.lib" section=res_tt
include "/home/meow/projects/ip_migration/pdks/smic18mmrf/smic18mmrf/../models/spectre/ms018_rf_v1p5_diff_ind_spe.ckt"
include "/home/meow/projects/ip_migration/pdks/smic18mmrf/smic18mmrf/../models/spectre/ms018_rf_v1p5_spri_ind_spe.ckt"
include "/home/meow/projects/ip_migration/pdks/smic18mmrf/smic18mmrf/../models/spectre/ms018_rf_v1p5_var_spe.ckt"

// demo_ipm_tsmc018/test1/schematic
M14 (net048 net07 VDD VDD) pch3 l=1u w=10u m=4
M13 (net07 net07 VDD VDD) pch3 l=1u w=10u m=4
M26 (VDD VDD VDD VDD) pch3 l=1u w=10u m=4
M30 (net15 net10 net10 net10) pch3 l=2u w=21.0u m=2
M29 (net7 net10 net10 net10) pch3 l=2u w=21.0u m=2
M25 (VDD VDD VDD VDD) pch3 l=2u w=21.0u m=2
M4 (net15 VIP net10 net10) pch3 l=2u w=21.0u m=4
M18 (net7 VIN net10 net10) pch3 l=2u w=21.0u m=4
M19 (net4 net4 VDD VDD) pch3 l=2u w=21.0u m=4
M20 (net10 net4 VDD VDD) pch3 l=2u w=21.0u m=8
M21 (VOUT net4 VDD VDD) pch3 l=2u w=21.0u m=16
M16 (net048 net048 GND GND) nch3 l=1u w=10u m=4
M15 (net07 net048 net08 GND) nch3 l=1u w=10u m=8
M24 (GND GND GND GND) nch3 l=1.2u w=15.0u m=2
M23 (GND GND GND GND) nch3 l=1.2u w=14.4u m=2
M17 (net4 net048 GND GND) nch3 l=1u w=10u m=8
M22 (GND GND GND GND) nch3 l=1u w=10u m=2
M7 (VOUT net15 GND GND) nch3 l=1.2u w=15.0u m=4
M6 (net15 net7 GND GND) nch3 l=1.2u w=14.4u m=1
M5 (net7 net7 GND GND) nch3 l=1.2u w=14.4u m=1
C1 (net25 VOUT) mimcap l=28.0u w=28.0u m=2
//Series configuration of R3
R3_1__dmy0 (net15 R3_1__dmy0 ) rnpo1rpo l=2.38u w=1u m=1
R3_2__dmy0 (R3_1__dmy0 net25 ) rnpo1rpo l=2.38u w=1u m=1
//End of R3

//Series configuration of R2
R2_1__dmy0 (net08 R2_1__dmy0 ) rnpo1rpo l=2.1u w=1u m=1
R2_2__dmy0 (R2_1__dmy0 GND ) rnpo1rpo l=2.1u w=1u m=1
//End of R2

simulatorOptions options temp=27
